; Generated from measured ngspice data. Display only; no Spectre run is implied.
; Full-resolution measurements and simulator logs remain beside this file.
printf("\nIMPORTED ngspice 45.2 / FreePDK45 results from Virtuoso netlist\n")
printf("Netlist SHA256: 7adea9ec6399ffd0bae31fb8b2bf1640a05611e5e080a55ad495219ff32cf0bc\n")
newWindow()
displayMode('strip)
let((rows n x y ctl watts k w)
  ; charging: time in seconds, Vop in volts, active control in volts, VDD power in watts
  rows = list(
    list(0 0.54 0 1.75089373e-05)
    list(4e-14 0.539999801 0.008 2.78273549e-05)
    list(6.4e-13 0.539996787 0.128 2.71947477e-05)
    list(2.64e-12 0.540005176 0.528 6.37343857e-05)
    list(4.64e-12 0.540348255 0.928 0.000124285292)
    list(5.35e-12 0.540588138 1 8.5914983e-05)
    list(7.25e-12 0.541169741 1 7.22291651e-05)
    list(9.25e-12 0.541676382 1 6.60013702e-05)
    list(1.125e-11 0.542130735 1 6.29577503e-05)
    list(1.325e-11 0.542557724 1 6.12790354e-05)
    list(1.525e-11 0.542969036 1 6.02488872e-05)
    list(1.725e-11 0.543370651 1 5.95569855e-05)
    list(1.925e-11 0.543765855 1 5.90562992e-05)
    list(2.125e-11 0.544156564 1 5.86714056e-05)
    list(2.325e-11 0.544543945 1 5.83609639e-05)
    list(2.525e-11 0.544928744 1 5.81009777e-05)
    list(2.725e-11 0.545311459 1 5.78767903e-05)
    list(2.925e-11 0.545692431 1 5.76790275e-05)
    list(3.015e-11 0.545865955 0.97 1.75635804e-05)
    list(3.175e-11 0.546062271 0.65 -1.19740115e-05)
    list(3.375e-11 0.546112015 0.25 -1.25899678e-05)
    list(3.505e-11 0.546119494 0 2.20924222e-05)
    list(3.625e-11 0.54611948 0 2.25099288e-05)
    list(3.825e-11 0.546119461 0 2.07128428e-05)
    list(4.025e-11 0.546119446 0 1.99075811e-05)
    list(4.225e-11 0.546119432 0 1.95311324e-05)
    list(4.425e-11 0.546119419 0 1.93209111e-05)
    list(4.625e-11 0.546119406 0 1.91711048e-05)
    list(4.825e-11 0.546119394 0 1.90345524e-05)
    list(5.025e-11 0.546119382 0 1.8887038e-05)
    list(5.225e-11 0.54611937 0 1.8719692e-05)
    list(5.425e-11 0.546119358 0 1.85388575e-05)
    list(5.625e-11 0.546119348 0 1.83592155e-05)
    list(5.825e-11 0.546119338 0 1.8194686e-05)
    list(6.025e-11 0.546119329 0 1.80536019e-05)
    list(6.225e-11 0.546119321 0 1.79383199e-05)
    list(6.425e-11 0.546119314 0 1.78471186e-05)
    list(6.625e-11 0.546119307 0 1.77763782e-05)
    list(6.825e-11 0.546119302 0 1.77220751e-05)
    list(7.025e-11 0.546119296 0 1.76805296e-05)
    list(7.225e-11 0.546119291 0 1.7648676e-05)
    list(7.425e-11 0.546119286 0 1.76240893e-05)
    list(7.625e-11 0.546119281 0 1.76049122e-05)
    list(7.825e-11 0.546119276 0 1.75897514e-05)
    list(8.025e-11 0.546119271 0 1.75775757e-05)
    list(8.225e-11 0.546119267 0 1.75676282e-05)
    list(8.425e-11 0.546119262 0 1.75593557e-05)
    list(8.625e-11 0.546119257 0 1.75523548e-05)
    list(8.825e-11 0.546119253 0 1.75463309e-05)
    list(9.025e-11 0.546119248 0 1.75410683e-05)
    list(9.225e-11 0.546119243 0 1.75364082e-05)
    list(9.425e-11 0.546119239 0 1.75322326e-05)
    list(9.625e-11 0.546119234 0 1.75284536e-05)
    list(9.825e-11 0.54611923 0 1.75250045e-05)
    list(1e-10 0.546119225 2.58493941e-15 1.75211423e-05)
    list(1.0075e-10 0.546115207 0.15 2.68801964e-05)
    list(1.0275e-10 0.5461249 0.55 6.60587164e-05)
    list(1.0475e-10 0.546470186 0.95 0.000126371988)
    list(1.0535e-10 0.54666766 1 8.66658762e-05)
    list(1.0725e-10 0.547226481 1 7.23210347e-05)
    list(1.0925e-10 0.547716618 1 6.57101058e-05)
    list(1.1125e-10 0.548158951 1 6.24528745e-05)
    list(1.1325e-10 0.548576584 1 6.065649e-05)
    list(1.1525e-10 0.548980159 1 5.9562868e-05)
    list(1.1725e-10 0.549375042 1 5.88384113e-05)
    list(1.1925e-10 0.549764152 1 5.83226353e-05)
    list(1.2125e-10 0.550149176 1 5.79324192e-05)
    list(1.2325e-10 0.550531146 1 5.76220246e-05)
    list(1.2525e-10 0.550910721 1 5.73649542e-05)
    list(1.2725e-10 0.551288343 1 5.71451403e-05)
    list(1.2925e-10 0.55166432 1 5.69524223e-05)
    list(1.3015e-10 0.551835957 0.97 1.69552904e-05)
    list(1.3175e-10 0.552033942 0.65 -1.22017703e-05)
    list(1.3375e-10 0.552085657 0.25 -1.27431494e-05)
    list(1.3505e-10 0.552093539 0 2.20957984e-05)
    list(1.3625e-10 0.552093524 0 2.25071968e-05)
    list(1.3825e-10 0.552093506 0 2.07051701e-05)
    list(1.4025e-10 0.552093491 0 1.98982506e-05)
    list(1.4225e-10 0.552093477 0 1.95212531e-05)
    list(1.4425e-10 0.552093465 0 1.93106516e-05)
    list(1.4625e-10 0.552093452 0 1.91600699e-05)
    list(1.4825e-10 0.55209344 0 1.90219303e-05)
    list(1.5025e-10 0.552093428 0 1.8872128e-05)
    list(1.5225e-10 0.552093417 0 1.87028106e-05)
    list(1.5425e-10 0.552093405 0 1.85213667e-05)
    list(1.5625e-10 0.552093395 0 1.83426887e-05)
    list(1.5825e-10 0.552093385 0 1.81802424e-05)
    list(1.6025e-10 0.552093377 0 1.80417153e-05)
    list(1.6225e-10 0.552093369 0 1.79289518e-05)
    list(1.6425e-10 0.552093362 0 1.78399517e-05)
    list(1.6625e-10 0.552093356 0 1.7771004e-05)
    list(1.6825e-10 0.55209335 0 1.77180982e-05)
    list(1.7025e-10 0.552093345 0 1.7677612e-05)
    list(1.7225e-10 0.55209334 0 1.76465463e-05)
    list(1.7425e-10 0.552093335 0 1.76225383e-05)
    list(1.7625e-10 0.55209333 0 1.76037829e-05)
    list(1.7825e-10 0.552093325 0 1.75889279e-05)
    list(1.8025e-10 0.552093321 0 1.75769732e-05)
    list(1.8225e-10 0.552093316 0 1.75671855e-05)
    list(1.8425e-10 0.552093311 0 1.75590287e-05)
    list(1.8625e-10 0.552093307 0 1.7552112e-05)
    list(1.8825e-10 0.552093302 0 1.75461497e-05)
    list(1.9025e-10 0.552093298 0 1.75409325e-05)
    list(1.9225e-10 0.552093293 0 1.75363061e-05)
    list(1.9425e-10 0.552093288 0 1.7532156e-05)
    list(1.9625e-10 0.552093284 0 1.75283965e-05)
    list(1.9825e-10 0.552093279 0 1.75249625e-05)
    list(2e-10 0.552093275 0 1.75211128e-05)
    list(2.0075e-10 0.552089069 0.15 2.68974273e-05)
    list(2.0275e-10 0.552097205 0.55 6.59553529e-05)
    list(2.0475e-10 0.552440648 0.95 0.000125786374)
    list(2.0535e-10 0.552635556 1 8.57515357e-05)
    list(2.0725e-10 0.553186867 1 7.14609504e-05)
    list(2.0925e-10 0.553670172 1 6.48839302e-05)
    list(2.1125e-10 0.554106328 1 6.16497845e-05)
    list(2.1325e-10 0.554518206 1 5.98728944e-05)
    list(2.1525e-10 0.554916325 1 5.87966888e-05)
    list(2.1725e-10 0.555305974 1 5.80876556e-05)
    list(2.1925e-10 0.555690019 1 5.7585343e-05)
    list(2.2125e-10 0.55607011 1 5.72068044e-05)
    list(2.2325e-10 0.55644725 1 5.69065572e-05)
    list(2.2525e-10 0.556822081 1 5.66583733e-05)
    list(2.2725e-10 0.557195029 1 5.64464293e-05)
    list(2.2925e-10 0.557566393 1 5.62607693e-05)
    list(2.3015e-10 0.557736279 0.97 1.64022743e-05)
    list(2.3175e-10 0.557935879 0.65 -1.2425411e-05)
    list(2.3375e-10 0.557989493 0.25 -1.28959521e-05)
    list(2.3505e-10 0.557997776 0 2.20991715e-05)
    list(2.3625e-10 0.557997762 0 2.25044109e-05)
    list(2.3825e-10 0.557997743 0 2.06974053e-05)
    list(2.4025e-10 0.557997728 0 1.98888018e-05)
    list(2.4225e-10 0.557997715 0 1.95112216e-05)
    list(2.4425e-10 0.557997703 0 1.93001813e-05)
    list(2.4625e-10 0.55799769 0 1.91487232e-05)
    list(2.4825e-10 0.557997678 0 1.90088611e-05)
    list(2.5025e-10 0.557997667 0 1.8856692e-05)
    list(2.5225e-10 0.557997655 0 1.86854629e-05)
    list(2.5425e-10 0.557997644 0 1.8503563e-05)
    list(2.5625e-10 0.557997634 0 1.83260111e-05)
    list(2.5825e-10 0.557997625 0 1.81657678e-05)
    list(2.6025e-10 0.557997617 0 1.80298648e-05)
    list(2.6225e-10 0.557997609 0 1.79196465e-05)
    list(2.6425e-10 0.557997602 0 1.78328512e-05)
    list(2.6625e-10 0.557997596 0 1.7765689e-05)
    list(2.6825e-10 0.557997591 0 1.77141704e-05)
    list(2.7025e-10 0.557997585 0 1.76747329e-05)
    list(2.7225e-10 0.55799758 0 1.76444461e-05)
    list(2.7425e-10 0.557997575 0 1.76210096e-05)
    list(2.7625e-10 0.557997571 0 1.76026701e-05)
    list(2.7825e-10 0.557997566 0 1.75881163e-05)
    list(2.8025e-10 0.557997561 0 1.75763794e-05)
    list(2.8225e-10 0.557997557 0 1.75667489e-05)
    list(2.8425e-10 0.557997552 0 1.75587061e-05)
    list(2.8625e-10 0.557997547 0 1.75518721e-05)
    list(2.8825e-10 0.557997543 0 1.75459703e-05)
    list(2.9025e-10 0.557997538 0 1.75407976e-05)
    list(2.9225e-10 0.557997534 0 1.75362043e-05)
    list(2.9425e-10 0.557997529 0 1.75320791e-05)
    list(2.9625e-10 0.557997525 0 1.75283386e-05)
    list(2.9825e-10 0.55799752 0 1.75249195e-05)
    list(3e-10 0.557997516 0 1.75210819e-05)
    list(3.0075e-10 0.557993122 0.15 2.69133555e-05)
    list(3.0275e-10 0.557999717 0.55 6.58496609e-05)
    list(3.0475e-10 0.558341262 0.95 0.00012521049)
    list(3.0535e-10 0.558533722 1 8.4866674e-05)
    list(3.0725e-10 0.559077853 1 7.06368758e-05)
    list(3.0925e-10 0.559554654 1 6.40973134e-05)
    list(3.1125e-10 0.559984948 1 6.08886837e-05)
    list(3.1325e-10 0.560391381 1 5.91330311e-05)
    list(3.1525e-10 0.560784354 1 5.80753729e-05)
    list(3.1725e-10 0.561169078 1 5.7382392e-05)
    list(3.1925e-10 0.561548366 1 5.68938025e-05)
    list(3.2125e-10 0.56192383 1 5.65269502e-05)
    list(3.2325e-10 0.562296446 1 5.62366985e-05)
    list(3.2525e-10 0.562666833 1 5.59971519e-05)
    list(3.2725e-10 0.563035406 1 5.57927723e-05)
    list(3.2925e-10 0.563402452 1 5.56138348e-05)
    list(3.3015e-10 0.563570696 0.97 1.58993835e-05)
    list(3.3175e-10 0.563771847 0.65 -1.26406259e-05)
    list(3.3375e-10 0.56382729 0.25 -1.30440884e-05)
    list(3.3505e-10 0.563835972 0 2.21026071e-05)
    list(3.3625e-10 0.563835958 0 2.25016157e-05)
    list(3.3825e-10 0.563835939 0 2.06895788e-05)
    list(3.4025e-10 0.563835925 0 1.98792556e-05)
    list(3.4225e-10 0.563835911 0 1.95010497e-05)
    list(3.4425e-10 0.563835899 0 1.92895026e-05)
    list(3.4625e-10 0.563835887 0 1.91370566e-05)
    list(3.4825e-10 0.563835875 0 1.89953334e-05)
    list(3.5025e-10 0.563835864 0 1.88407319e-05)
    list(3.5225e-10 0.563835853 0 1.86676699e-05)
    list(3.5425e-10 0.563835842 0 1.84854777e-05)
    list(3.5625e-10 0.563835832 0 1.83092133e-05)
    list(3.5825e-10 0.563835823 0 1.81512858e-05)
    list(3.6025e-10 0.563835815 0 1.80180645e-05)
    list(3.6225e-10 0.563835807 0 1.79104093e-05)
    list(3.6425e-10 0.563835801 0 1.78258149e-05)
    list(3.6625e-10 0.563835795 0 1.77604259e-05)
    list(3.6825e-10 0.563835789 0 1.77102799e-05)
    list(3.7025e-10 0.563835784 0 1.76718779e-05)
    list(3.7225e-10 0.563835779 0 1.76423587e-05)
    list(3.7425e-10 0.563835774 0 1.76194848e-05)
    list(3.7625e-10 0.563835769 0 1.76015543e-05)
    list(3.7825e-10 0.563835764 0 1.75872966e-05)
    list(3.8025e-10 0.56383576 0 1.75757735e-05)
    list(3.8225e-10 0.563835755 0 1.75662975e-05)
    list(3.8425e-10 0.56383575 0 1.75583664e-05)
    list(3.8625e-10 0.563835746 0 1.75516137e-05)
    list(3.8825e-10 0.563835741 0 1.75457712e-05)
    list(3.9025e-10 0.563835737 0 1.75406422e-05)
    list(3.9225e-10 0.563835732 0 1.75360814e-05)
    list(3.9425e-10 0.563835728 0 1.75319808e-05)
    list(3.9625e-10 0.563835723 0 1.75282591e-05)
    list(3.9825e-10 0.563835719 0 1.75248546e-05)
    list(4e-10 0.563835715 0 1.7521029e-05)
    list(4.0075e-10 0.563831134 0.15 2.69280066e-05)
    list(4.0275e-10 0.563836203 0.55 6.574177e-05)
    list(4.0475e-10 0.56417578 0.95 0.000124641536)
    list(4.0535e-10 0.564365889 1 8.40077277e-05)
    list(4.0725e-10 0.564903123 1 6.98449594e-05)
    list(4.0925e-10 0.565373704 1 6.33462194e-05)
    list(4.1125e-10 0.565798414 1 6.01654681e-05)
    list(4.1325e-10 0.566199681 1 5.84327268e-05)
    list(4.1525e-10 0.566587786 1 5.73946512e-05)
    list(4.1725e-10 0.566967865 1 5.67182453e-05)
    list(4.1925e-10 0.567342673 1 5.62435389e-05)
    list(4.2125e-10 0.567713786 1 5.58882975e-05)
    list(4.2325e-10 0.56808215 1 5.56078237e-05)
    list(4.2525e-10 0.568448366 1 5.53766162e-05)
    list(4.2725e-10 0.568812832 1 5.51794615e-05)
    list(4.2925e-10 0.569175824 1 5.50068885e-05)
    list(4.3015e-10 0.569342522 0.97 1.54393533e-05)
    list(4.3175e-10 0.569545169 0.65 -1.28434525e-05)
    list(4.3375e-10 0.569602376 0.25 -1.31833095e-05)
    list(4.3505e-10 0.569611456 0 2.21061002e-05)
    list(4.3625e-10 0.569611441 0 2.24988081e-05)
    list(4.3825e-10 0.569611423 0 2.06816941e-05)
    list(4.4025e-10 0.569611408 0 1.98696139e-05)
    list(4.4225e-10 0.569611395 0 1.94907347e-05)
    list(4.4425e-10 0.569611383 0 1.92786052e-05)
    list(4.4625e-10 0.569611371 0 1.91250511e-05)
    list(4.4825e-10 0.56961136 0 1.8981327e-05)
    list(4.5025e-10 0.569611348 0 1.88242431e-05)
    list(4.5225e-10 0.569611337 0 1.86494458e-05)
    list(4.5425e-10 0.569611327 0 1.84671336e-05)
    list(4.5625e-10 0.569611317 0 1.8292317e-05)
    list(4.5825e-10 0.569611308 0 1.81368106e-05)
    list(4.6025e-10 0.5696113 0 1.80063197e-05)
    list(4.6225e-10 0.569611293 0 1.79012374e-05)
    list(4.6425e-10 0.569611286 0 1.78188344e-05)
    list(4.6625e-10 0.56961128 0 1.77552015e-05)
    list(4.6825e-10 0.569611274 0 1.77064104e-05)
    list(4.7025e-10 0.569611269 0 1.76690281e-05)
    list(4.7225e-10 0.569611264 0 1.76402637e-05)
    list(4.7425e-10 0.569611259 0 1.76179422e-05)
    list(4.7625e-10 0.569611254 0 1.76004132e-05)
    list(4.7825e-10 0.56961125 0 1.75864458e-05)
    list(4.8025e-10 0.569611245 0 1.75751324e-05)
    list(4.8225e-10 0.56961124 0 1.75658079e-05)
    list(4.8425e-10 0.569611236 0 1.75579864e-05)
    list(4.8625e-10 0.569611231 0 1.75513134e-05)
    list(4.8825e-10 0.569611226 0 1.75455292e-05)
    list(4.9025e-10 0.569611222 0 1.75404433e-05)
    list(4.9225e-10 0.569611217 0 1.75359146e-05)
    list(4.9425e-10 0.569611213 0 1.75318383e-05)
    list(4.9625e-10 0.569611208 0 1.75281353e-05)
    list(4.9825e-10 0.569611203 0 1.75247454e-05)
    list(5e-10 0.569611199 0 1.75209321e-05)
    list(5.0075e-10 0.569606433 0.15 2.69415484e-05)
    list(5.0275e-10 0.569609991 0.55 6.56320758e-05)
    list(5.0475e-10 0.569947534 0.95 0.000124076241)
    list(5.0535e-10 0.57013537 1 8.31704093e-05)
    list(5.0725e-10 0.570665951 1 6.90809451e-05)
    list(5.0925e-10 0.571130563 1 6.26264404e-05)
    list(5.1125e-10 0.571549935 1 5.94759917e-05)
    list(5.1325e-10 0.571946284 1 5.77678275e-05)
    list(5.1525e-10 0.572329772 1 5.67503041e-05)
    list(5.1725e-10 0.572705454 1 5.60909081e-05)
    list(5.1925e-10 0.573076032 1 5.56301599e-05)
    list(5.2125e-10 0.573443041 1 5.52863841e-05)
    list(5.2325e-10 0.573807397 1 5.50154175e-05)
    list(5.2525e-10 0.574169682 1 5.47922149e-05)
    list(5.2725e-10 0.574530278 1 5.46019233e-05)
    list(5.2925e-10 0.574889453 1 5.44353455e-05)
    list(5.3015e-10 0.575054688 0.97 1.50154297e-05)
    list(5.3175e-10 0.575258785 0.65 -1.30299229e-05)
    list(5.3375e-10 0.575317696 0.25 -1.33093723e-05)
    list(5.3505e-10 0.575327173 0 2.21096429e-05)
    list(5.3625e-10 0.575327158 0 2.24959821e-05)
    list(5.3825e-10 0.57532714 0 2.06737506e-05)
    list(5.4025e-10 0.575327125 0 1.98598751e-05)
    list(5.4225e-10 0.575327112 0 1.948027e-05)
    list(5.4425e-10 0.5753271 0 1.92674748e-05)
    list(5.4625e-10 0.575327088 0 1.91126839e-05)
    list(5.4825e-10 0.575327077 0 1.89668201e-05)
    list(5.5025e-10 0.575327066 0 1.88072218e-05)
    list(5.5225e-10 0.575327055 0 1.86308047e-05)
    list(5.5425e-10 0.575327044 0 1.84485522e-05)
    list(5.5625e-10 0.575327035 0 1.82753406e-05)
    list(5.5825e-10 0.575327026 0 1.81223526e-05)
    list(5.6025e-10 0.575327018 0 1.79946321e-05)
    list(5.6225e-10 0.575327011 0 1.78921255e-05)
    list(5.6425e-10 0.575327004 0 1.78118983e-05)
    list(5.6625e-10 0.575326998 0 1.77500006e-05)
    list(5.6825e-10 0.575326993 0 1.77025439e-05)
    list(5.7025e-10 0.575326987 0 1.76661637e-05)
    list(5.7225e-10 0.575326982 0 1.76381399e-05)
    list(5.7425e-10 0.575326977 0 1.76163598e-05)
    list(5.7625e-10 0.575326972 0 1.75992239e-05)
    list(5.7825e-10 0.575326968 0 1.75855409e-05)
    list(5.8025e-10 0.575326963 0 1.75744328e-05)
    list(5.8225e-10 0.575326958 0 1.75652566e-05)
    list(5.8425e-10 0.575326953 0 1.75575427e-05)
    list(5.8625e-10 0.575326949 0 1.7550948e-05)
    list(5.8825e-10 0.575326944 0 1.75452212e-05)
    list(5.9025e-10 0.575326939 0 1.75401778e-05)
    list(5.9225e-10 0.575326935 0 1.75356811e-05)
    list(5.9425e-10 0.57532693 0 1.75316291e-05)
    list(5.9625e-10 0.575326925 0 1.75279449e-05)
    list(5.9825e-10 0.575326921 0 1.75245699e-05)
    list(6e-10 0.575326917 0 1.75207694e-05)
    list(6.0075e-10 0.575321964 0.15 2.69541336e-05)
    list(6.0275e-10 0.575324028 0.55 6.55209242e-05)
    list(6.0475e-10 0.575659471 0.95 0.000123511643)
    list(6.0535e-10 0.575845098 1 8.23507126e-05)
    list(6.0725e-10 0.576369232 1 6.83407994e-05)
    list(6.0925e-10 0.576828092 1 6.19339927e-05)
    list(6.1125e-10 0.577242344 1 5.88162606e-05)
    list(6.1325e-10 0.577633994 1 5.71343411e-05)
    list(6.1525e-10 0.578013086 1 5.61382698e-05)
    list(6.1725e-10 0.578384595 1 5.549623e-05)
    list(6.1925e-10 0.578751164 1 5.50494344e-05)
    list(6.2125e-10 0.579114286 1 5.47169157e-05)
    list(6.2325e-10 0.579474851 1 5.44551442e-05)
    list(6.2525e-10 0.579833416 1 5.42395875e-05)
    list(6.2725e-10 0.580190352 1 5.40557858e-05)
    list(6.2925e-10 0.580545914 1 5.38948316e-05)
    list(6.3015e-10 0.580709761 0.97 1.46214633e-05)
    list(6.3175e-10 0.580915268 0.65 -1.31964463e-05)
    list(6.3375e-10 0.580975829 0.25 -1.34184266e-05)
    list(6.3505e-10 0.580985702 0 2.21132253e-05)
    list(6.3625e-10 0.580985688 0 2.24931304e-05)
    list(6.3825e-10 0.580985669 0 2.06657458e-05)
    list(6.4025e-10 0.580985655 0 1.98500348e-05)
    list(6.4225e-10 0.580985642 0 1.94696467e-05)
    list(6.4425e-10 0.58098563 0 1.9256095e-05)
    list(6.4625e-10 0.580985618 0 1.90999309e-05)
    list(6.4825e-10 0.580985606 0 1.89517925e-05)
    list(6.5025e-10 0.580985595 0 1.87896668e-05)
    list(6.5225e-10 0.580985584 0 1.86117632e-05)
    list(6.5425e-10 0.580985574 0 1.84297555e-05)
    list(6.5625e-10 0.580985565 0 1.82583021e-05)
    list(6.5825e-10 0.580985556 0 1.81079216e-05)
    list(6.6025e-10 0.580985548 0 1.79830029e-05)
    list(6.6225e-10 0.580985541 0 1.78830676e-05)
    list(6.6425e-10 0.580985534 0 1.78049961e-05)
    list(6.6625e-10 0.580985528 0 1.77448092e-05)
    list(6.6825e-10 0.580985523 0 1.76986639e-05)
    list(6.7025e-10 0.580985517 0 1.76632665e-05)
    list(6.7225e-10 0.580985512 0 1.76359679e-05)
    list(6.7425e-10 0.580985507 0 1.76147176e-05)
    list(6.7625e-10 0.580985502 0 1.75979662e-05)
    list(6.7825e-10 0.580985497 0 1.75845612e-05)
    list(6.8025e-10 0.580985492 0 1.75736539e-05)
    list(6.8225e-10 0.580985488 0 1.7564623e-05)
    list(6.8425e-10 0.580985483 0 1.75570145e-05)
    list(6.8625e-10 0.580985478 0 1.75504968e-05)
    list(6.8825e-10 0.580985473 0 1.75448267e-05)
    list(6.9025e-10 0.580985469 0 1.75398255e-05)
    list(6.9225e-10 0.580985464 0 1.75353607e-05)
    list(6.9425e-10 0.580985459 0 1.75313332e-05)
    list(6.9625e-10 0.580985454 0 1.75276682e-05)
    list(6.9825e-10 0.580985449 0 1.75243086e-05)
    list(7e-10 0.580985445 0 1.75205216e-05)
    list(7.0075e-10 0.580980307 0.15 2.69658995e-05)
    list(7.0275e-10 0.580980893 0.55 6.54086129e-05)
    list(7.0475e-10 0.581314171 0.95 0.000122945086)
    list(7.0535e-10 0.58149764 1 8.15449375e-05)
    list(7.0725e-10 0.582015501 1 6.76207571e-05)
    list(7.0925e-10 0.582468792 1 6.12651661e-05)
    list(7.1125e-10 0.582878113 1 5.81827297e-05)
    list(7.1325e-10 0.58326526 1 5.6528611e-05)
    list(7.1525e-10 0.583640153 1 5.55547671e-05)
    list(7.1725e-10 0.584007685 1 5.4930316e-05)
    list(7.1925e-10 0.58437044 1 5.44973794e-05)
    list(7.2125e-10 0.584729868 1 5.41758497e-05)
    list(7.2325e-10 0.585086828 1 5.39229237e-05)
    list(7.2525e-10 0.58544186 1 5.37146356e-05)
    list(7.2725e-10 0.585795317 1 5.35369455e-05)
    list(7.2925e-10 0.586147446 1 5.33812477e-05)
    list(7.3015e-10 0.586309966 0.97 1.42519538e-05)
    list(7.3175e-10 0.586516851 0.65 -1.33401535e-05)
    list(7.3375e-10 0.586579013 0.25 -1.35073731e-05)
    list(7.3505e-10 0.586589282 0 2.21168295e-05)
    list(7.3625e-10 0.586589268 0 2.24902408e-05)
    list(7.3825e-10 0.586589249 0 2.06576737e-05)
    list(7.4025e-10 0.586589234 0 1.98400869e-05)
    list(7.4225e-10 0.586589222 0 1.94588543e-05)
    list(7.4425e-10 0.58658921 0 1.92444483e-05)
    list(7.4625e-10 0.586589198 0 1.90867679e-05)
    list(7.4825e-10 0.586589186 0 1.89362264e-05)
    list(7.5025e-10 0.586589175 0 1.87715815e-05)
    list(7.5225e-10 0.586589165 0 1.8592341e-05)
    list(7.5425e-10 0.586589154 0 1.84107671e-05)
    list(7.5625e-10 0.586589145 0 1.82412203e-05)
    list(7.5825e-10 0.586589136 0 1.80935277e-05)
    list(7.6025e-10 0.586589128 0 1.79714341e-05)
    list(7.6225e-10 0.586589121 0 1.78740597e-05)
    list(7.6425e-10 0.586589115 0 1.77981192e-05)
    list(7.6625e-10 0.586589109 0 1.77396156e-05)
    list(7.6825e-10 0.586589103 0 1.7694757e-05)
    list(7.7025e-10 0.586589098 0 1.76603217e-05)
    list(7.7225e-10 0.586589092 0 1.76337322e-05)
    list(7.7425e-10 0.586589087 0 1.76129994e-05)
    list(7.7625e-10 0.586589082 0 1.75966234e-05)
    list(7.7825e-10 0.586589077 0 1.75834899e-05)
    list(7.8025e-10 0.586589072 0 1.7572779e-05)
    list(7.8225e-10 0.586589067 0 1.75638903e-05)
    list(7.8425e-10 0.586589062 0 1.75563852e-05)
    list(7.8625e-10 0.586589058 0 1.75499432e-05)
    list(7.8825e-10 0.586589053 0 1.75443292e-05)
    list(7.9025e-10 0.586589048 0 1.753937e-05)
    list(7.9225e-10 0.586589043 0 1.75349372e-05)
    list(7.9425e-10 0.586589038 0 1.75309346e-05)
    list(7.9625e-10 0.586589033 0 1.75272894e-05)
    list(7.9825e-10 0.586589028 0 1.7523946e-05)
    list(8e-10 0.586589024 0 1.75201736e-05)
    list(8.0075e-10 0.586583701 0.15 2.69769693e-05)
    list(8.0275e-10 0.586582825 0.55 6.52953945e-05)
    list(8.0475e-10 0.586913876 0.95 0.00012237422)
    list(8.0535e-10 0.587095223 1 8.0749703e-05)
    list(8.0725e-10 0.587606953 1 6.69173516e-05)
    list(8.0925e-10 0.588054833 1 6.06165581e-05)
    list(8.1125e-10 0.588459386 1 5.75720155e-05)
    list(8.1325e-10 0.588842199 1 5.59471796e-05)
    list(8.1525e-10 0.589213067 1 5.49962278e-05)
    list(8.1725e-10 0.589576794 1 5.43894972e-05)
    list(8.1925e-10 0.589935905 1 5.39702514e-05)
    list(8.2125e-10 0.590291806 1 5.36593954e-05)
    list(8.2325e-10 0.590645326 1 5.34149418e-05)
    list(8.2525e-10 0.590996984 1 5.3213538e-05)
    list(8.2725e-10 0.591347119 1 5.30415856e-05)
    list(8.2925e-10 0.591695967 1 5.28907889e-05)
    list(8.3015e-10 0.591857215 0.97 1.39020522e-05)
    list(8.3175e-10 0.592065449 0.65 -1.34591718e-05)
    list(8.3375e-10 0.59212917 0.25 -1.35741252e-05)
    list(8.3505e-10 0.592139834 0 2.21204389e-05)
    list(8.3625e-10 0.592139819 0 2.2487303e-05)
    list(8.3825e-10 0.5921398 0 2.06495292e-05)
    list(8.4025e-10 0.592139786 0 1.98300255e-05)
    list(8.4225e-10 0.592139773 0 1.9447883e-05)
    list(8.4425e-10 0.592139761 0 1.92325181e-05)
    list(8.4625e-10 0.592139749 0 1.90731729e-05)
    list(8.4825e-10 0.592139738 0 1.8920109e-05)
    list(8.5025e-10 0.592139727 0 1.87529755e-05)
    list(8.5225e-10 0.592139716 0 1.85725627e-05)
    list(8.5425e-10 0.592139706 0 1.83916144e-05)
    list(8.5625e-10 0.592139697 0 1.82241165e-05)
    list(8.5825e-10 0.592139688 0 1.80791835e-05)
    list(8.6025e-10 0.59213968 0 1.79599305e-05)
    list(8.6225e-10 0.592139673 0 1.78651008e-05)
    list(8.6425e-10 0.592139667 0 1.77912628e-05)
    list(8.6625e-10 0.592139661 0 1.77344128e-05)
    list(8.6825e-10 0.592139655 0 1.76908143e-05)
    list(8.7025e-10 0.592139649 0 1.76573195e-05)
    list(8.7225e-10 0.592139644 0 1.76314223e-05)
    list(8.7425e-10 0.592139639 0 1.76111944e-05)
    list(8.7625e-10 0.592139633 0 1.75951845e-05)
    list(8.7825e-10 0.592139628 0 1.7582316e-05)
    list(8.8025e-10 0.592139623 0 1.75717968e-05)
    list(8.8225e-10 0.592139618 0 1.75630472e-05)
    list(8.8425e-10 0.592139613 0 1.75556436e-05)
    list(8.8625e-10 0.592139608 0 1.75492762e-05)
    list(8.8825e-10 0.592139603 0 1.75437178e-05)
    list(8.9025e-10 0.592139598 0 1.75388006e-05)
    list(8.9225e-10 0.592139593 0 1.75344001e-05)
    list(8.9425e-10 0.592139588 0 1.75304229e-05)
    list(8.9625e-10 0.592139583 0 1.75267981e-05)
    list(8.9825e-10 0.592139578 0 1.75234717e-05)
    list(9e-10 0.592139574 0 1.75197152e-05)
    list(9.0075e-10 0.592134065 0.15 2.69874521e-05)
    list(9.0275e-10 0.592131746 0.55 6.51814804e-05)
    list(9.0475e-10 0.592460508 0.95 0.000121796988)
    list(9.0535e-10 0.59263976 1 7.996196e-05)
    list(9.0725e-10 0.593145472 1 6.62274408e-05)
    list(9.0925e-10 0.593588071 1 5.99850979e-05)
    list(9.1125e-10 0.593987997 1 5.69809275e-05)
    list(9.1325e-10 0.594366625 1 5.53868174e-05)
    list(9.1525e-10 0.594733617 1 5.44593272e-05)
    list(9.1725e-10 0.595093691 1 5.38703616e-05)
    list(9.1925e-10 0.595449305 1 5.34645775e-05)
    list(9.2125e-10 0.595801822 1 5.31640457e-05)
    list(9.2325e-10 0.596152042 1 5.29276783e-05)
    list(9.2525e-10 0.596500462 1 5.27327765e-05)
    list(9.2725e-10 0.596847408 1 5.25661999e-05)
    list(9.2925e-10 0.597193108 1 5.24199666e-05)
    list(9.3015e-10 0.597353128 0.97 1.35675382e-05)
    list(9.3175e-10 0.597562689 0.65 -1.35528056e-05)
    list(9.3375e-10 0.597627926 0.25 -1.3617795e-05)
    list(9.3505e-10 0.597638986 0 2.21240376e-05)
    list(9.3625e-10 0.597638971 0 2.24843085e-05)
    list(9.3825e-10 0.597638952 0 2.06413079e-05)
    list(9.4025e-10 0.597638938 0 1.98198458e-05)
    list(9.4225e-10 0.597638925 0 1.94367244e-05)
    list(9.4425e-10 0.597638913 0 1.92202892e-05)
    list(9.4625e-10 0.597638901 0 1.90591271e-05)
    list(9.4825e-10 0.59763889 0 1.89034343e-05)
    list(9.5025e-10 0.597638879 0 1.87338656e-05)
    list(9.5225e-10 0.597638868 0 1.85524591e-05)
    list(9.5425e-10 0.597638858 0 1.83723291e-05)
    list(9.5625e-10 0.597638849 0 1.82070157e-05)
    list(9.5825e-10 0.59763884 0 1.80649055e-05)
    list(9.6025e-10 0.597638832 0 1.79485011e-05)
    list(9.6225e-10 0.597638825 0 1.78561948e-05)
    list(9.6425e-10 0.597638819 0 1.77844276e-05)
    list(9.6625e-10 0.597638813 0 1.77291992e-05)
    list(9.6825e-10 0.597638807 0 1.7686833e-05)
    list(9.7025e-10 0.597638801 0 1.76542564e-05)
    list(9.7225e-10 0.597638796 0 1.76290341e-05)
    list(9.7425e-10 0.59763879 0 1.76092982e-05)
    list(9.7625e-10 0.597638785 0 1.75936452e-05)
    list(9.7825e-10 0.59763878 0 1.7581035e-05)
    list(9.8025e-10 0.597638775 0 1.7570703e-05)
    list(9.8225e-10 0.597638769 0 1.75620894e-05)
    list(9.8425e-10 0.597638764 0 1.75547854e-05)
    list(9.8625e-10 0.597638759 0 1.75484917e-05)
    list(9.8825e-10 0.597638754 0 1.75429884e-05)
    list(9.9025e-10 0.597638749 0 1.75381132e-05)
    list(9.9225e-10 0.597638744 0 1.75337453e-05)
    list(9.9425e-10 0.597638739 0 1.75297941e-05)
    list(9.9625e-10 0.597638733 0 1.75261907e-05)
    list(9.9825e-10 0.597638728 0 1.75228821e-05)
    list(1e-09 0.597638724 0 1.75191428e-05)
    list(1.00075e-09 0.597633029 0.15 2.69974446e-05)
    list(1.00275e-09 0.597629285 0.55 6.50670453e-05)
    list(1.00475e-09 0.597955699 0.95 0.000121211614)
    list(1.00535e-09 0.598132873 1 7.9178987e-05)
    list(1.00725e-09 0.598632652 1 6.55482175e-05)
    list(1.00925e-09 0.599070078 1 5.93680569e-05)
    list(1.01125e-09 0.599465499 1 5.64067736e-05)
    list(1.01325e-09 0.599840069 1 5.48446825e-05)
    list(1.01525e-09 0.600203318 1 5.39410839e-05)
    list(1.01725e-09 0.600559867 1 5.33698256e-05)
    list(1.01925e-09 0.600912111 1 5.29772112e-05)
    list(1.02125e-09 0.601261367 1 5.26866235e-05)
    list(1.02325e-09 0.601608406 1 5.24579478e-05)
    list(1.02525e-09 0.601953704 1 5.2269172e-05)
    list(1.02725e-09 0.602297575 1 5.21076238e-05)
    list(1.02925e-09 0.602640236 1 5.19656369e-05)
    list(1.03015e-09 0.602799063 0.97 1.32447801e-05)
    list(1.03175e-09 0.603009932 0.65 -1.36215988e-05)
    list(1.03375e-09 0.603076651 0.25 -1.36387695e-05)
    list(1.03505e-09 0.603088107 0 2.21276028e-05)
    list(1.03625e-09 0.603088092 0 2.24812464e-05)
    list(1.03825e-09 0.603088072 0 2.06330052e-05)
    list(1.04025e-09 0.603088058 0 1.98095438e-05)
    list(1.04225e-09 0.603088045 0 1.94253716e-05)
    list(1.04425e-09 0.603088033 0 1.9207749e-05)
    list(1.04625e-09 0.603088021 0 1.9044616e-05)
    list(1.04825e-09 0.60308801 0 1.88862032e-05)
    list(1.05025e-09 0.603087999 0 1.87142762e-05)
    list(1.05225e-09 0.603087988 0 1.85320672e-05)
    list(1.05425e-09 0.603087978 0 1.83529477e-05)
    list(1.05625e-09 0.603087969 0 1.81899473e-05)
    list(1.05825e-09 0.603087961 0 1.80507142e-05)
    list(1.06025e-09 0.603087953 0 1.79371598e-05)
    list(1.06225e-09 0.603087946 0 1.7847351e-05)
    list(1.06425e-09 0.603087939 0 1.77776202e-05)
    list(1.06625e-09 0.603087933 0 1.77239799e-05)
    list(1.06825e-09 0.603087927 0 1.76828173e-05)
    list(1.07025e-09 0.603087921 0 1.76511358e-05)
    list(1.07225e-09 0.603087916 0 1.7626571e-05)
    list(1.07425e-09 0.60308791 0 1.7607314e-05)
    list(1.07625e-09 0.603087905 0 1.75920085e-05)
    list(1.07825e-09 0.603087899 0 1.75796499e-05)
    list(1.08025e-09 0.603087894 0 1.75695005e-05)
    list(1.08225e-09 0.603087889 0 1.756102e-05)
    list(1.08425e-09 0.603087883 0 1.75538137e-05)
    list(1.08625e-09 0.603087878 0 1.75475926e-05)
    list(1.08825e-09 0.603087873 0 1.7542144e-05)
    list(1.09025e-09 0.603087868 0 1.75373108e-05)
    list(1.09225e-09 0.603087862 0 1.7532976e-05)
    list(1.09425e-09 0.603087857 0 1.75290514e-05)
    list(1.09625e-09 0.603087852 0 1.75254701e-05)
    list(1.09825e-09 0.603087847 0 1.75221803e-05)
    list(1.1e-09 0.603087842 0 1.75184596e-05)
    list(1.10075e-09 0.603081961 0.15 2.70070309e-05)
    list(1.10275e-09 0.603076812 0.55 6.49522309e-05)
    list(1.10475e-09 0.603400817 0.95 0.000120616581)
    list(1.10535e-09 0.60357592 1 7.83983849e-05)
    list(1.10725e-09 0.604069834 1 6.48772109e-05)
    list(1.10925e-09 0.604502174 1 5.87630436e-05)
    list(1.11125e-09 0.604893191 1 5.58471077e-05)
    list(1.11325e-09 0.605263816 1 5.43181899e-05)
    list(1.11525e-09 0.605623434 1 5.34387838e-05)
    list(1.11725e-09 0.60597657 1 5.2885086e-05)
    list(1.11925e-09 0.606325551 1 5.25052995e-05)
    list(1.12125e-09 0.606671651 1 5.22242555e-05)
    list(1.12325e-09 0.607015609 1 5.20028774e-05)
    list(1.12525e-09 0.607357882 1 5.18198681e-05)
    list(1.12725e-09 0.607698771 1 5.16630193e-05)
    list(1.12925e-09 0.608038483 1 5.1524979e-05)
    list(1.13015e-09 0.608196149 0.97 1.29306823e-05)
    list(1.13175e-09 0.608408309 0.65 -1.36672962e-05)
    list(1.13375e-09 0.608476477 0.25 -1.36386578e-05)
    list(1.13505e-09 0.608488329 0 2.21311137e-05)
    list(1.13625e-09 0.608488314 0 2.24781089e-05)
    list(1.13825e-09 0.608488294 0 2.06246188e-05)
    list(1.14025e-09 0.60848828 0 1.9799118e-05)
    list(1.14225e-09 0.608488267 0 1.941382e-05)
    list(1.14425e-09 0.608488255 0 1.91948875e-05)
    list(1.14625e-09 0.608488243 0 1.90296299e-05)
    list(1.14825e-09 0.608488232 0 1.88684243e-05)
    list(1.15025e-09 0.608488221 0 1.86942394e-05)
    list(1.15225e-09 0.60848821 0 1.85114296e-05)
    list(1.15425e-09 0.6084882 0 1.83335112e-05)
    list(1.15625e-09 0.608488191 0 1.81729444e-05)
    list(1.15825e-09 0.608488182 0 1.80366345e-05)
    list(1.16025e-09 0.608488175 0 1.79259249e-05)
    list(1.16225e-09 0.608488167 0 1.78385837e-05)
    list(1.16425e-09 0.608488161 0 1.77708525e-05)
    list(1.16625e-09 0.608488155 0 1.77187656e-05)
    list(1.16825e-09 0.608488148 0 1.76787772e-05)
    list(1.17025e-09 0.608488143 0 1.76479676e-05)
    list(1.17225e-09 0.608488137 0 1.76240424e-05)
    list(1.17425e-09 0.608488131 0 1.76052513e-05)
    list(1.17625e-09 0.608488126 0 1.75902837e-05)
    list(1.17825e-09 0.60848812 0 1.75781702e-05)
    list(1.18025e-09 0.608488115 0 1.75681987e-05)
    list(1.18225e-09 0.608488109 0 1.75598483e-05)
    list(1.18425e-09 0.608488104 0 1.7552738e-05)
    list(1.18625e-09 0.608488098 0 1.75465883e-05)
    list(1.18825e-09 0.608488093 0 1.7541194e-05)
    list(1.19025e-09 0.608488088 0 1.75364029e-05)
    list(1.19225e-09 0.608488082 0 1.75321015e-05)
    list(1.19425e-09 0.608488077 0 1.75282041e-05)
    list(1.19625e-09 0.608488071 0 1.75246456e-05)
    list(1.19825e-09 0.608488066 0 1.75213755e-05)
    list(1.2e-09 0.608488061 4.13590306e-14 1.75176746e-05)
    list(1.20075e-09 0.608481993 0.15 2.70162844e-05)
    list(1.20275e-09 0.608475459 0.55 6.48371505e-05)
    list(1.20475e-09 0.608796997 0.95 0.000120010625)
    list(1.20535e-09 0.608970031 1 7.76180654e-05)
    list(1.20725e-09 0.609458123 1 6.42122798e-05)
    list(1.20925e-09 0.609885447 1 5.81679908e-05)
    list(1.21125e-09 0.610272149 1 5.52997755e-05)
    list(1.21325e-09 0.610638924 1 5.3805031e-05)
    list(1.21525e-09 0.61099501 1 5.29499905e-05)
    list(1.21725e-09 0.611344827 1 5.24136247e-05)
    list(1.21925e-09 0.611690637 1 5.20462836e-05)
    list(1.22125e-09 0.612033666 1 5.17743818e-05)
    list(1.22325e-09 0.612374626 1 5.15599112e-05)
    list(1.22525e-09 0.612713954 1 5.13823107e-05)
    list(1.22725e-09 0.613051938 1 5.12298543e-05)
    list(1.22925e-09 0.613388778 1 5.10954896e-05)
    list(1.23015e-09 0.613545303 0.97 1.26226302e-05)
    list(1.23175e-09 0.613758743 0.65 -1.36927229e-05)
    list(1.23375e-09 0.61382833 0.25 -1.36201714e-05)
    list(1.23505e-09 0.613840579 0 2.21345503e-05)
    list(1.23625e-09 0.613840563 0 2.24748901e-05)
    list(1.23825e-09 0.613840543 0 2.06161486e-05)
    list(1.24025e-09 0.613840529 0 1.9788569e-05)
    list(1.24225e-09 0.613840516 0 1.94020676e-05)
    list(1.24425e-09 0.613840504 0 1.91816976e-05)
    list(1.24625e-09 0.613840492 0 1.9014164e-05)
    list(1.24825e-09 0.613840481 0 1.88501139e-05)
    list(1.25025e-09 0.61384047 0 1.86737944e-05)
    list(1.25225e-09 0.613840459 0 1.84905944e-05)
    list(1.25425e-09 0.613840449 0 1.83140648e-05)
    list(1.25625e-09 0.61384044 0 1.81560438e-05)
    list(1.25825e-09 0.613840432 0 1.80226949e-05)
    list(1.26025e-09 0.613840424 0 1.79148189e-05)
    list(1.26225e-09 0.613840417 0 1.78299121e-05)
    list(1.26425e-09 0.61384041 0 1.77641418e-05)
    list(1.26625e-09 0.613840403 0 1.77135723e-05)
    list(1.26825e-09 0.613840397 0 1.76747284e-05)
    list(1.27025e-09 0.613840391 0 1.76447671e-05)
    list(1.27225e-09 0.613840385 0 1.76214639e-05)
    list(1.27425e-09 0.61384038 0 1.76031255e-05)
    list(1.27625e-09 0.613840374 0 1.75884864e-05)
    list(1.27825e-09 0.613840368 0 1.75766112e-05)
    list(1.28025e-09 0.613840363 0 1.75668132e-05)
    list(1.28225e-09 0.613840357 0 1.75585899e-05)
    list(1.28425e-09 0.613840352 0 1.75515735e-05)
    list(1.28625e-09 0.613840346 0 1.75454943e-05)
    list(1.28825e-09 0.61384034 0 1.75401538e-05)
    list(1.29025e-09 0.613840335 0 1.75354047e-05)
    list(1.29225e-09 0.613840329 0 1.75311369e-05)
    list(1.29425e-09 0.613840324 0 1.75272672e-05)
    list(1.29625e-09 0.613840318 0 1.75237321e-05)
    list(1.29825e-09 0.613840313 0 1.75204824e-05)
    list(1.3e-09 0.613840308 0 1.75168024e-05)
    list(1.30075e-09 0.613834052 0.15 2.70252684e-05)
    list(1.30275e-09 0.613826153 0.55 6.47218922e-05)
    list(1.30475e-09 0.614145165 0.95 0.00011939268)
    list(1.30535e-09 0.614316126 1 7.68362332e-05)
    list(1.30725e-09 0.614798423 1 6.35516038e-05)
    list(1.30925e-09 0.615220788 1 5.75811422e-05)
    list(1.31125e-09 0.615603249 1 5.47629027e-05)
    list(1.31325e-09 0.615966257 1 5.33031687e-05)
    list(1.31525e-09 0.616318893 1 5.24725441e-05)
    list(1.31725e-09 0.616665472 1 5.19532401e-05)
    list(1.31925e-09 0.617008186 1 5.15979221e-05)
    list(1.32125e-09 0.617348217 1 5.13347185e-05)
    list(1.32325e-09 0.617686247 1 5.11267785e-05)
    list(1.32525e-09 0.618022695 1 5.09542638e-05)
    list(1.32725e-09 0.618357836 1 5.08059154e-05)
    list(1.32925e-09 0.618691863 1 5.06749767e-05)
    list(1.33015e-09 0.618847267 0.97 1.23184357e-05)
    list(1.33175e-09 0.619061974 0.65 -1.37015983e-05)
    list(1.33375e-09 0.619132954 0.25 -1.35869355e-05)
    list(1.33505e-09 0.619145599 0 2.21378942e-05)
    list(1.33625e-09 0.619145583 0 2.24715867e-05)
    list(1.33825e-09 0.619145564 0 2.06075964e-05)
    list(1.34025e-09 0.619145549 0 1.97778999e-05)
    list(1.34225e-09 0.619145536 0 1.93901146e-05)
    list(1.34425e-09 0.619145524 0 1.91681749e-05)
    list(1.34625e-09 0.619145512 0 1.89982188e-05)
    list(1.34825e-09 0.619145501 0 1.88312957e-05)
    list(1.35025e-09 0.61914549 0 1.86529865e-05)
    list(1.35225e-09 0.619145479 0 1.84696143e-05)
    list(1.35425e-09 0.619145469 0 1.82946567e-05)
    list(1.35625e-09 0.61914546 0 1.8139285e-05)
    list(1.35825e-09 0.619145452 0 1.80089266e-05)
    list(1.36025e-09 0.619145444 0 1.7903868e-05)
    list(1.36225e-09 0.619145437 0 1.7821359e-05)
    list(1.36425e-09 0.61914543 0 1.77575093e-05)
    list(1.36625e-09 0.619145423 0 1.77084208e-05)
    list(1.36825e-09 0.619145417 0 1.76706912e-05)
    list(1.37025e-09 0.619145411 0 1.76415548e-05)
    list(1.37225e-09 0.619145405 0 1.76188556e-05)
    list(1.37425e-09 0.619145399 0 1.76009569e-05)
    list(1.37625e-09 0.619145393 0 1.75866369e-05)
    list(1.37825e-09 0.619145387 0 1.75749934e-05)
    list(1.38025e-09 0.619145382 0 1.75653643e-05)
    list(1.38225e-09 0.619145376 0 1.7557265e-05)
    list(1.38425e-09 0.61914537 0 1.75503405e-05)
    list(1.38625e-09 0.619145364 0 1.75443307e-05)
    list(1.38825e-09 0.619145359 0 1.75390434e-05)
    list(1.39025e-09 0.619145353 0 1.75343361e-05)
    list(1.39225e-09 0.619145347 0 1.75301019e-05)
    list(1.39425e-09 0.619145342 0 1.75262602e-05)
    list(1.39625e-09 0.619145336 0 1.7522749e-05)
    list(1.39825e-09 0.61914533 0 1.75195204e-05)
    list(1.4e-09 0.619145325 0 1.75158622e-05)
    list(1.40075e-09 0.619138882 0.15 2.70340369e-05)
    list(1.40275e-09 0.619129637 0.55 6.46065229e-05)
    list(1.40475e-09 0.619446067 0.95 0.000118761875)
    list(1.40535e-09 0.619614943 1 7.60513898e-05)
    list(1.40725e-09 0.620091459 1 6.2893682e-05)
    list(1.40925e-09 0.620508909 1 5.70009916e-05)
    list(1.41125e-09 0.620887191 1 5.42348058e-05)
    list(1.41325e-09 0.621246503 1 5.28107865e-05)
    list(1.41525e-09 0.621595759 1 5.20045271e-05)
    list(1.41725e-09 0.621939168 1 5.15019084e-05)
    list(1.41925e-09 0.622278848 1 5.11581828e-05)
    list(1.42125e-09 0.62261594 1 5.09032781e-05)
    list(1.42325e-09 0.622951095 1 5.07015082e-05)
    list(1.42525e-09 0.623284714 1 5.0533772e-05)
    list(1.42725e-09 0.623617062 1 5.038927e-05)
    list(1.42925e-09 0.623948324 1 5.02615306e-05)
    list(1.43015e-09 0.624102619 0.97 1.20162844e-05)
    list(1.43175e-09 0.624318582 0.65 -1.36983088e-05)
    list(1.43375e-09 0.624390931 0.25 -1.35432532e-05)
    list(1.43505e-09 0.624403974 0 2.21411313e-05)
    list(1.43625e-09 0.624403958 0 2.24681993e-05)
    list(1.43825e-09 0.624403938 0 2.05989674e-05)
    list(1.44025e-09 0.624403924 0 1.97671159e-05)
    list(1.44225e-09 0.624403911 0 1.93779632e-05)
    list(1.44425e-09 0.624403899 0 1.91543173e-05)
    list(1.44625e-09 0.624403887 0 1.89818e-05)
    list(1.44825e-09 0.624403875 0 1.88119999e-05)
    list(1.45025e-09 0.624403864 0 1.86318667e-05)
    list(1.45225e-09 0.624403854 0 1.84485453e-05)
    list(1.45425e-09 0.624403844 0 1.82753374e-05)
    list(1.45625e-09 0.624403835 0 1.81227096e-05)
    list(1.45825e-09 0.624403826 0 1.79953636e-05)
    list(1.46025e-09 0.624403818 0 1.78931006e-05)
    list(1.46225e-09 0.624403811 0 1.78129504e-05)
    list(1.46425e-09 0.624403804 0 1.77509797e-05)
    list(1.46625e-09 0.624403798 0 1.77033354e-05)
    list(1.46825e-09 0.624403791 0 1.76666898e-05)
    list(1.47025e-09 0.624403785 0 1.76383546e-05)
    list(1.47225e-09 0.624403779 0 1.76162418e-05)
    list(1.47425e-09 0.624403773 0 1.75987697e-05)
    list(1.47625e-09 0.624403767 0 1.75847595e-05)
    list(1.47825e-09 0.624403761 0 1.75733411e-05)
    list(1.48025e-09 0.624403755 0 1.75638763e-05)
    list(1.48225e-09 0.624403749 0 1.75558978e-05)
    list(1.48425e-09 0.624403743 0 1.75490633e-05)
    list(1.48625e-09 0.624403737 0 1.75431214e-05)
    list(1.48825e-09 0.624403731 0 1.75378866e-05)
    list(1.49025e-09 0.624403726 0 1.75332207e-05)
    list(1.49225e-09 0.62440372 0 1.75290202e-05)
    list(1.49425e-09 0.624403714 0 1.75252065e-05)
    list(1.49625e-09 0.624403708 0 1.75217195e-05)
    list(1.49825e-09 0.624403702 0 1.75185122e-05)
    list(1.5e-09 0.624403697 4.13590306e-14 1.75148763e-05)
    list(1.50075e-09 0.624397066 0.15 2.70426359e-05)
    list(1.50275e-09 0.624386497 0.55 6.44910908e-05)
    list(1.50475e-09 0.624700285 0.95 0.000118117511)
    list(1.50535e-09 0.624867062 1 7.52621858e-05)
    list(1.50725e-09 0.625337799 1 6.22372435e-05)
    list(1.50925e-09 0.625750368 1 5.64263517e-05)
    list(1.51125e-09 0.626124527 1 5.3714209e-05)
    list(1.51325e-09 0.626480204 1 5.23263658e-05)
    list(1.51525e-09 0.62682614 1 5.15443528e-05)
    list(1.51725e-09 0.627166433 1 5.10579244e-05)
    list(1.51925e-09 0.627503132 1 5.07253369e-05)
    list(1.52125e-09 0.627837331 1 5.04783222e-05)
    list(1.52325e-09 0.628169654 1 5.02823777e-05)
    list(1.52525e-09 0.628500486 1 5.01191345e-05)
    list(1.52725e-09 0.62883008 1 4.99782399e-05)
    list(1.52925e-09 0.629158613 1 4.98534954e-05)
    list(1.53015e-09 0.629311808 0.97 1.17146944e-05)
    list(1.53175e-09 0.629529018 0.65 -1.36876597e-05)
    list(1.53375e-09 0.629602714 0.25 -1.349387e-05)
    list(1.53505e-09 0.629616156 0 2.21442414e-05)
    list(1.53625e-09 0.629616139 0 2.24647251e-05)
    list(1.53825e-09 0.629616119 0 2.05902652e-05)
    list(1.54025e-09 0.629616105 0 1.97562219e-05)
    list(1.54225e-09 0.629616091 0 1.93656154e-05)
    list(1.54425e-09 0.629616079 0 1.91401237e-05)
    list(1.54625e-09 0.629616067 0 1.89649164e-05)
    list(1.54825e-09 0.629616056 0 1.87922618e-05)
    list(1.55025e-09 0.629616045 0 1.8610489e-05)
    list(1.55225e-09 0.629616034 0 1.84274447e-05)
    list(1.55425e-09 0.629616025 0 1.82561577e-05)
    list(1.55625e-09 0.629616015 0 1.8106359e-05)
    list(1.55825e-09 0.629616007 0 1.79820398e-05)
    list(1.56025e-09 0.629615999 0 1.78825465e-05)
    list(1.56225e-09 0.629615992 0 1.78047136e-05)
    list(1.56425e-09 0.629615985 0 1.77445796e-05)
    list(1.56625e-09 0.629615978 0 1.7698342e-05)
    list(1.56825e-09 0.629615971 0 1.76627503e-05)
    list(1.57025e-09 0.629615965 0 1.7635193e-05)
    list(1.57225e-09 0.629615959 0 1.7613649e-05)
    list(1.57425e-09 0.629615953 0 1.75965907e-05)
    list(1.57625e-09 0.629615947 0 1.75828809e-05)
    list(1.57825e-09 0.62961594 0 1.7571681e-05)
    list(1.58025e-09 0.629615934 0 1.75623758e-05)
    list(1.58225e-09 0.629615928 0 1.75545149e-05)
    list(1.58425e-09 0.629615922 0 1.75477682e-05)
    list(1.58625e-09 0.629615916 0 1.75418929e-05)
    list(1.58825e-09 0.62961591 0 1.75367095e-05)
    list(1.59025e-09 0.629615904 0 1.75320845e-05)
    list(1.59225e-09 0.629615898 0 1.75279173e-05)
    list(1.59425e-09 0.629615892 0 1.75241317e-05)
    list(1.59625e-09 0.629615886 0 1.75206688e-05)
    list(1.59825e-09 0.62961588 0 1.75174829e-05)
    list(1.6e-09 0.629615875 0 1.75138696e-05)
    list(1.60075e-09 0.629609054 0.15 2.70511039e-05)
    list(1.60275e-09 0.629597183 0.55 6.43756286e-05)
    list(1.60475e-09 0.629908271 0.95 0.00011745904)
    list(1.60535e-09 0.630072931 1 7.4467688e-05)
    list(1.60725e-09 0.63053788 1 6.15813211e-05)
    list(1.60925e-09 0.630945595 1 5.58562265e-05)
    list(1.61125e-09 0.631315678 1 5.31998539e-05)
    list(1.61325e-09 0.631667772 1 5.18486572e-05)
    list(1.61525e-09 0.63201044 1 5.10904315e-05)
    list(1.61725e-09 0.632347663 1 5.06197907e-05)
    list(1.61925e-09 0.632681421 1 5.02978813e-05)
    list(1.62125e-09 0.633012764 1 5.00583588e-05)
    list(1.62325e-09 0.633342289 1 4.9867914e-05)
    list(1.62525e-09 0.633670364 1 4.97088997e-05)
    list(1.62725e-09 0.633997232 1 4.95713948e-05)
    list(1.62925e-09 0.634323064 1 4.9449461e-05)
    list(1.63015e-09 0.634475166 0.97 1.14124557e-05)
    list(1.63175e-09 0.634693613 0.65 -1.36746015e-05)
    list(1.63375e-09 0.634768637 0.25 -1.34436616e-05)
    list(1.63505e-09 0.634782477 0 2.21472171e-05)
    list(1.63625e-09 0.63478246 0 2.24611696e-05)
    list(1.63825e-09 0.63478244 0 2.05814982e-05)
    list(1.64025e-09 0.634782425 0 1.97452257e-05)
    list(1.64225e-09 0.634782412 0 1.93530748e-05)
    list(1.64425e-09 0.6347824 0 1.91255947e-05)
    list(1.64625e-09 0.634782388 0 1.89475817e-05)
    list(1.64825e-09 0.634782377 0 1.87721215e-05)
    list(1.65025e-09 0.634782365 0 1.85889104e-05)
    list(1.65225e-09 0.634782355 0 1.84063706e-05)
    list(1.65425e-09 0.634782345 0 1.82371681e-05)
    list(1.65625e-09 0.634782336 0 1.80902741e-05)
    list(1.65825e-09 0.634782327 0 1.79689889e-05)
    list(1.66025e-09 0.634782319 0 1.7872235e-05)
    list(1.66225e-09 0.634782312 0 1.7796676e-05)
    list(1.66425e-09 0.634782305 0 1.77383354e-05)
    list(1.66625e-09 0.634782298 0 1.76934672e-05)
    list(1.66825e-09 0.634782291 0 1.76588992e-05)
    list(1.67025e-09 0.634782285 0 1.76320966e-05)
    list(1.67225e-09 0.634782279 0 1.7611104e-05)
    list(1.67425e-09 0.634782272 0 1.75944467e-05)
    list(1.67625e-09 0.634782266 0 1.75810281e-05)
    list(1.67825e-09 0.63478226 0 1.75700401e-05)
    list(1.68025e-09 0.634782254 0 1.75608899e-05)
    list(1.68225e-09 0.634782247 0 1.75531433e-05)
    list(1.68425e-09 0.634782241 0 1.7546482e-05)
    list(1.68625e-09 0.634782235 0 1.75406717e-05)
    list(1.68825e-09 0.634782229 0 1.75355387e-05)
    list(1.69025e-09 0.634782223 0 1.75309538e-05)
    list(1.69225e-09 0.634782216 0 1.75268194e-05)
    list(1.69425e-09 0.63478221 0 1.75230613e-05)
    list(1.69625e-09 0.634782204 0 1.75196224e-05)
    list(1.69825e-09 0.634782198 0 1.75164577e-05)
    list(1.7e-09 0.634782192 0 1.7512867e-05)
    list(1.70075e-09 0.634775182 0.15 2.70594732e-05)
    list(1.70275e-09 0.634762031 0.55 6.42601556e-05)
    list(1.70475e-09 0.635070359 0.95 0.000116786045)
    list(1.70535e-09 0.63523288 1 7.36670335e-05)
    list(1.70725e-09 0.635692027 1 6.09251754e-05)
    list(1.70925e-09 0.636094909 1 5.52898174e-05)
    list(1.71125e-09 0.636460956 1 5.2690728e-05)
    list(1.71325e-09 0.636809512 1 5.13762236e-05)
    list(1.71525e-09 0.637148952 1 5.06415403e-05)
    list(1.71725e-09 0.637483143 1 5.01862024e-05)
    list(1.71925e-09 0.637813992 1 4.98745126e-05)
    list(1.72125e-09 0.638142506 1 4.96421006e-05)
    list(1.72325e-09 0.638469259 1 4.94568513e-05)
    list(1.72525e-09 0.6387946 1 4.93018239e-05)
    list(1.72725e-09 0.639118764 1 4.91675124e-05)
    list(1.72925e-09 0.639441915 1 4.90482246e-05)
    list(1.73015e-09 0.639592924 0.97 1.11078943e-05)
    list(1.73175e-09 0.639812599 0.65 -1.36639502e-05)
    list(1.73375e-09 0.639888932 0.25 -1.33973693e-05)
    list(1.73505e-09 0.639903172 0 2.21500495e-05)
    list(1.73625e-09 0.639903155 0 2.24575369e-05)
    list(1.73825e-09 0.639903134 0 2.05726736e-05)
    list(1.74025e-09 0.639903119 0 1.97341337e-05)
    list(1.74225e-09 0.639903106 0 1.93403436e-05)
    list(1.74425e-09 0.639903094 0 1.91107306e-05)
    list(1.74625e-09 0.639903082 0 1.89298118e-05)
    list(1.74825e-09 0.639903071 0 1.87516216e-05)
    list(1.75025e-09 0.639903059 0 1.85671882e-05)
    list(1.75225e-09 0.639903049 0 1.83853796e-05)
    list(1.75425e-09 0.639903039 0 1.82184164e-05)
    list(1.75625e-09 0.63990303 0 1.80744933e-05)
    list(1.75825e-09 0.639903021 0 1.79562421e-05)
    list(1.76025e-09 0.639903013 0 1.78621935e-05)
    list(1.76225e-09 0.639903006 0 1.77888632e-05)
    list(1.76425e-09 0.639902999 0 1.77322721e-05)
    list(1.76625e-09 0.639902992 0 1.76887359e-05)
    list(1.76825e-09 0.639902985 0 1.76551617e-05)
    list(1.77025e-09 0.639902978 0 1.76290908e-05)
    list(1.77225e-09 0.639902972 0 1.76086325e-05)
    list(1.77425e-09 0.639902965 0 1.75923636e-05)
    list(1.77625e-09 0.639902959 0 1.7579227e-05)
    list(1.77825e-09 0.639902953 0 1.75684443e-05)
    list(1.78025e-09 0.639902946 0 1.75594443e-05)
    list(1.78225e-09 0.63990294 0 1.75518087e-05)
    list(1.78425e-09 0.639902933 0 1.75452304e-05)
    list(1.78625e-09 0.639902927 0 1.75394832e-05)
    list(1.78825e-09 0.639902921 0 1.75343994e-05)
    list(1.79025e-09 0.639902914 0 1.75298536e-05)
    list(1.79225e-09 0.639902908 0 1.75257513e-05)
    list(1.79425e-09 0.639902902 0 1.75220202e-05)
    list(1.79625e-09 0.639902895 0 1.75186047e-05)
    list(1.79825e-09 0.639902889 0 1.75154609e-05)
    list(1.8e-09 0.639902884 4.13590306e-14 1.75118923e-05)
    list(1.80075e-09 0.639895683 0.15 2.70677707e-05)
    list(1.80275e-09 0.639881272 0.55 6.41446799e-05)
    list(1.80475e-09 0.640186781 0.95 0.000116098221)
    list(1.80535e-09 0.640347141 1 7.28595897e-05)
    list(1.80725e-09 0.640800464 1 6.02682715e-05)
    list(1.80925e-09 0.641198529 1 5.47264895e-05)
    list(1.81125e-09 0.641560577 1 5.21862407e-05)
    list(1.81325e-09 0.641905634 1 5.0908197e-05)
    list(1.81525e-09 0.64224188 1 5.01966174e-05)
    list(1.81725e-09 0.642573068 1 4.9756064e-05)
    list(1.81925e-09 0.642901034 1 4.94541344e-05)
    list(1.82125e-09 0.643226741 1 4.92284652e-05)
    list(1.82325e-09 0.643550739 1 4.90481263e-05)
    list(1.82525e-09 0.643873363 1 4.88968636e-05)
    list(1.82725e-09 0.644194836 1 4.87655675e-05)
    list(1.82925e-09 0.644515317 1 4.86487782e-05)
    list(1.83015e-09 0.644665236 0.97 1.08016244e-05)
    list(1.83175e-09 0.644886127 0.65 -1.36603051e-05)
    list(1.83375e-09 0.644963753 0.25 -1.3359488e-05)
    list(1.83505e-09 0.644978394 0 2.21527421e-05)
    list(1.83625e-09 0.644978377 0 2.24538388e-05)
    list(1.83825e-09 0.644978356 0 2.05638044e-05)
    list(1.84025e-09 0.644978341 0 1.97229561e-05)
    list(1.84225e-09 0.644978328 0 1.93274266e-05)
    list(1.84425e-09 0.644978316 0 1.90955349e-05)
    list(1.84625e-09 0.644978304 0 1.89116275e-05)
    list(1.84825e-09 0.644978292 0 1.8730809e-05)
    list(1.85025e-09 0.644978281 0 1.85453809e-05)
    list(1.85225e-09 0.644978271 0 1.83645274e-05)
    list(1.85425e-09 0.644978261 0 1.81999486e-05)
    list(1.85625e-09 0.644978251 0 1.80590528e-05)
    list(1.85825e-09 0.644978243 0 1.7943829e-05)
    list(1.86025e-09 0.644978235 0 1.78524478e-05)
    list(1.86225e-09 0.644978227 0 1.77812995e-05)
    list(1.86425e-09 0.64497822 0 1.77264137e-05)
    list(1.86625e-09 0.644978213 0 1.7684172e-05)
    list(1.86825e-09 0.644978206 0 1.76515618e-05)
    list(1.87025e-09 0.644978199 0 1.76261997e-05)
    list(1.87225e-09 0.644978193 0 1.76062587e-05)
    list(1.87425e-09 0.644978186 0 1.75903656e-05)
    list(1.87625e-09 0.644978179 0 1.75775019e-05)
    list(1.87825e-09 0.644978173 0 1.75669178e-05)
    list(1.88025e-09 0.644978166 0 1.75580632e-05)
    list(1.88225e-09 0.64497816 0 1.75505351e-05)
    list(1.88425e-09 0.644978153 0 1.75440372e-05)
    list(1.88625e-09 0.644978147 0 1.75383512e-05)
    list(1.88825e-09 0.64497814 0 1.7533315e-05)
    list(1.89025e-09 0.644978134 0 1.75288072e-05)
    list(1.89225e-09 0.644978127 0 1.75247359e-05)
    list(1.89425e-09 0.644978121 0 1.75210311e-05)
    list(1.89625e-09 0.644978114 0 1.75176383e-05)
    list(1.89825e-09 0.644978108 0 1.75145147e-05)
    list(1.9e-09 0.644978102 0 1.75109674e-05)
    list(1.90075e-09 0.64497071 0.15 2.7076018e-05)
    list(1.90275e-09 0.644955063 0.55 6.40292001e-05)
    list(1.90475e-09 0.645257692 0.95 0.000115395357)
    list(1.90535e-09 0.645415865 1 7.20448949e-05)
    list(1.90725e-09 0.645863339 1 5.9610255e-05)
    list(1.90925e-09 0.646256602 1 5.41658505e-05)
    list(1.91125e-09 0.646614682 1 5.1685231e-05)
    list(1.91325e-09 0.646956272 1 5.04437219e-05)
    list(1.91525e-09 0.647289355 1 4.97547417e-05)
    list(1.91725e-09 0.647617563 1 4.9328437e-05)
    list(1.91925e-09 0.647942663 1 4.90358155e-05)
    list(1.92125e-09 0.648265579 1 4.88165393e-05)
    list(1.92325e-09 0.648586834 1 4.86408459e-05)
    list(1.92525e-09 0.64890675 1 4.8493145e-05)
    list(1.92725e-09 0.649225541 1 4.8364704e-05)
    list(1.92925e-09 0.649543361 1 4.8250281e-05)
    list(1.93015e-09 0.649692186 0.97 1.04924136e-05)
    list(1.93175e-09 0.649914283 0.65 -1.36676276e-05)
    list(1.93375e-09 0.649993188 0.25 -1.33338614e-05)
    list(1.93505e-09 0.65000823 0 2.21552929e-05)
    list(1.93625e-09 0.650008213 0 2.24500824e-05)
    list(1.93825e-09 0.650008192 0 2.05548989e-05)
    list(1.94025e-09 0.650008177 0 1.9711699e-05)
    list(1.94225e-09 0.650008163 0 1.93143241e-05)
    list(1.94425e-09 0.650008151 0 1.9080008e-05)
    list(1.94625e-09 0.650008139 0 1.88930497e-05)
    list(1.94825e-09 0.650008127 0 1.87097295e-05)
    list(1.95025e-09 0.650008116 0 1.85235441e-05)
    list(1.95225e-09 0.650008106 0 1.83438651e-05)
    list(1.95425e-09 0.650008096 0 1.81818053e-05)
    list(1.95625e-09 0.650008087 0 1.80439834e-05)
    list(1.95825e-09 0.650008078 0 1.7931774e-05)
    list(1.96025e-09 0.65000807 0 1.78430191e-05)
    list(1.96225e-09 0.650008062 0 1.77740046e-05)
    list(1.96425e-09 0.650008055 0 1.77207794e-05)
    list(1.96625e-09 0.650008048 0 1.76797948e-05)
    list(1.96825e-09 0.650008041 0 1.7648119e-05)
    list(1.97025e-09 0.650008034 0 1.76234433e-05)
    list(1.97225e-09 0.650008027 0 1.76040026e-05)
    list(1.97425e-09 0.65000802 0 1.75884729e-05)
    list(1.97625e-09 0.650008014 0 1.7575873e-05)
    list(1.97825e-09 0.650008007 0 1.75654809e-05)
    list(1.98025e-09 0.650008 0 1.75567669e-05)
    list(1.98225e-09 0.650007994 0 1.75493425e-05)
    list(1.98425e-09 0.650007987 0 1.75429224e-05)
    list(1.98625e-09 0.65000798 0 1.75372955e-05)
    list(1.98825e-09 0.650007974 0 1.75323053e-05)
    list(1.99025e-09 0.650007967 0 1.7527834e-05)
    list(1.99225e-09 0.65000796 0 1.75237927e-05)
    list(1.99425e-09 0.650007954 0 1.7520113e-05)
    list(1.99625e-09 0.650007947 0 1.75167419e-05)
    list(1.99825e-09 0.65000794 0 1.75136376e-05)
    list(2e-09 0.650007935 0 1.75101107e-05)
    list(2.00075e-09 0.650000351 0.15 2.70842328e-05)
    list(2.00275e-09 0.649983488 0.55 6.39137069e-05)
    list(2.00475e-09 0.650283177 0.95 0.00011467732)
    list(2.00535e-09 0.650439136 1 7.12226414e-05)
    list(2.00725e-09 0.650880734 1 5.89509266e-05)
    list(2.00925e-09 0.651269207 1 5.36073023e-05)
    list(2.01125e-09 0.651623346 1 5.11871905e-05)
    list(2.01325e-09 0.651961498 1 4.99820065e-05)
    list(2.01525e-09 0.65229144 1 4.93150923e-05)
    list(2.01725e-09 0.652616686 1 4.8902502e-05)
    list(2.01925e-09 0.652938934 1 4.86187544e-05)
    list(2.02125e-09 0.653259068 1 4.84055437e-05)
    list(2.02325e-09 0.653577587 1 4.82342539e-05)
    list(2.02525e-09 0.6538948 1 4.80899328e-05)
    list(2.02725e-09 0.654210913 1 4.79642047e-05)
    list(2.02925e-09 0.654526073 1 4.78520323e-05)
    list(2.03015e-09 0.654673801 0.97 1.01798284e-05)
    list(2.03175e-09 0.654897092 0.65 -1.36892479e-05)
    list(2.03375e-09 0.654977263 0.25 -1.33236506e-05)
    list(2.03505e-09 0.654992707 0 2.21577123e-05)
    list(2.03625e-09 0.654992689 0 2.24462806e-05)
    list(2.03825e-09 0.654992668 0 2.0545968e-05)
    list(2.04025e-09 0.654992653 0 1.9700368e-05)
    list(2.04225e-09 0.654992639 0 1.93010351e-05)
    list(2.04425e-09 0.654992627 0 1.90641508e-05)
    list(2.04625e-09 0.654992615 0 1.88741013e-05)
    list(2.04825e-09 0.654992603 0 1.86884295e-05)
    list(2.05025e-09 0.654992592 0 1.85017309e-05)
    list(2.05225e-09 0.654992582 0 1.83234394e-05)
    list(2.05425e-09 0.654992572 0 1.81640225e-05)
    list(2.05625e-09 0.654992563 0 1.80293112e-05)
    list(2.05825e-09 0.654992554 0 1.79200969e-05)
    list(2.06025e-09 0.654992546 0 1.78339241e-05)
    list(2.06225e-09 0.654992538 0 1.77669941e-05)
    list(2.06425e-09 0.65499253 0 1.77153847e-05)
    list(2.06625e-09 0.654992523 0 1.76756199e-05)
    list(2.06825e-09 0.654992516 0 1.76448492e-05)
    list(2.07025e-09 0.654992509 0 1.76208375e-05)
    list(2.07225e-09 0.654992502 0 1.76018804e-05)
    list(2.07425e-09 0.654992495 0 1.75867018e-05)
    list(2.07625e-09 0.654992488 0 1.75743567e-05)
    list(2.07825e-09 0.654992482 0 1.75641499e-05)
    list(2.08025e-09 0.654992475 0 1.75555716e-05)
    list(2.08225e-09 0.654992468 0 1.75482474e-05)
    list(2.08425e-09 0.654992461 0 1.75419021e-05)
    list(2.08625e-09 0.654992454 0 1.75363322e-05)
    list(2.08825e-09 0.654992448 0 1.7531386e-05)
    list(2.09025e-09 0.654992441 0 1.75269498e-05)
    list(2.09225e-09 0.654992434 0 1.75229371e-05)
    list(2.09425e-09 0.654992427 0 1.75192814e-05)
    list(2.09625e-09 0.65499242 0 1.7515931e-05)
    list(2.09825e-09 0.654992414 0 1.75128449e-05)
    list(2.1e-09 0.654992408 0 1.75093372e-05)
    list(2.10075e-09 0.654984631 0.15 2.7092429e-05)
    list(2.10275e-09 0.654966576 0.55 6.37981843e-05)
    list(2.10475e-09 0.655263262 0.95 0.000113944041)
    list(2.10535e-09 0.65541698 1 7.03926648e-05)
    list(2.10725e-09 0.655852673 1 5.82902493e-05)
    list(2.10925e-09 0.656236367 1 5.30506769e-05)
    list(2.11125e-09 0.656586592 1 5.0691717e-05)
    list(2.11325e-09 0.656921329 1 4.95224959e-05)
    list(2.11525e-09 0.65724815 1 4.88770537e-05)
    list(2.11725e-09 0.657570448 1 4.84776318e-05)
    list(2.11925e-09 0.657889852 1 4.82023325e-05)
    list(2.12125e-09 0.658207209 1 4.79948769e-05)
    list(2.12325e-09 0.658522995 1 4.78277654e-05)
    list(2.12525e-09 0.658837506 1 4.7686657e-05)
    list(2.12725e-09 0.659150941 1 4.75635125e-05)
    list(2.12925e-09 0.659463441 1 4.74534857e-05)
    list(2.13015e-09 0.659610068 0.97 9.8635642e-06)
    list(2.13175e-09 0.659834539 0.65 -1.37277163e-05)
    list(2.13375e-09 0.659915963 0.25 -1.33311675e-05)
    list(2.13505e-09 0.659931809 0 2.21599936e-05)
    list(2.13625e-09 0.659931791 0 2.24424342e-05)
    list(2.13825e-09 0.65993177 0 2.05370145e-05)
    list(2.14025e-09 0.659931755 0 1.96889626e-05)
    list(2.14225e-09 0.659931741 0 1.92875534e-05)
    list(2.14425e-09 0.659931729 0 1.90479613e-05)
    list(2.14625e-09 0.659931717 0 1.88548043e-05)
    list(2.14825e-09 0.659931705 0 1.8666953e-05)
    list(2.15025e-09 0.659931694 0 1.84799901e-05)
    list(2.15225e-09 0.659931683 0 1.83032915e-05)
    list(2.15425e-09 0.659931674 0 1.81466298e-05)
    list(2.15625e-09 0.659931664 0 1.80150566e-05)
    list(2.15825e-09 0.659931656 0 1.79088125e-05)
    list(2.16025e-09 0.659931647 0 1.78251748e-05)
    list(2.16225e-09 0.659931639 0 1.77602791e-05)
    list(2.16425e-09 0.659931632 0 1.77102404e-05)
    list(2.16625e-09 0.659931624 0 1.76716585e-05)
    list(2.16825e-09 0.659931617 0 1.76417639e-05)
    list(2.17025e-09 0.65993161 0 1.76183941e-05)
    list(2.17225e-09 0.659931603 0 1.75999042e-05)
    list(2.17425e-09 0.659931596 0 1.75850645e-05)
    list(2.17625e-09 0.659931589 0 1.75729653e-05)
    list(2.17825e-09 0.659931582 0 1.75629373e-05)
    list(2.18025e-09 0.659931575 0 1.75544896e-05)
    list(2.18225e-09 0.659931568 0 1.75472618e-05)
    list(2.18425e-09 0.659931561 0 1.75409885e-05)
    list(2.18625e-09 0.659931554 0 1.75354732e-05)
    list(2.18825e-09 0.659931547 0 1.75305693e-05)
    list(2.19025e-09 0.65993154 0 1.75261665e-05)
    list(2.19225e-09 0.659931533 0 1.7522181e-05)
    list(2.19425e-09 0.659931526 0 1.75185479e-05)
    list(2.19625e-09 0.659931519 0 1.75152169e-05)
    list(2.19825e-09 0.659931512 0 1.75121478e-05)
    list(2.2e-09 0.659931506 0 1.75086578e-05)
    list(2.20075e-09 0.659923536 0.15 2.71006156e-05)
    list(2.20275e-09 0.65990431 0.55 6.36826094e-05)
    list(2.20475e-09 0.66019793 0.95 0.000113195517)
    list(2.20535e-09 0.66034938 1 6.95549386e-05)
    list(2.20725e-09 0.660779139 1 5.76282788e-05)
    list(2.20925e-09 0.661158065 1 5.2496204e-05)
    list(2.21125e-09 0.661504397 1 5.0198288e-05)
    list(2.21325e-09 0.661835741 1 4.90646122e-05)
    list(2.21525e-09 0.662159454 1 4.84400344e-05)
    list(2.21725e-09 0.662478813 1 4.80532461e-05)
    list(2.21925e-09 0.66279538 1 4.77859922e-05)
    list(2.22125e-09 0.663109961 1 4.75840032e-05)
    list(2.22325e-09 0.663423014 1 4.74208651e-05)
    list(2.22525e-09 0.663734821 1 4.72828194e-05)
    list(2.22725e-09 0.664045574 1 4.71621438e-05)
    list(2.22925e-09 0.66435541 1 4.70541702e-05)
    list(2.23015e-09 0.664500931 0.97 9.54342306e-06)
    list(2.23175e-09 0.664726566 0.65 -1.37847322e-05)
    list(2.23375e-09 0.664809234 0.25 -1.33579103e-05)
    list(2.23505e-09 0.664825483 0 2.2162176e-05)
    list(2.23625e-09 0.664825465 0 2.24385718e-05)
    list(2.23825e-09 0.664825444 0 2.05280559e-05)
    list(2.24025e-09 0.664825428 0 1.96774904e-05)
    list(2.24225e-09 0.664825414 0 1.92738773e-05)
    list(2.24425e-09 0.664825402 0 1.90314426e-05)
    list(2.24625e-09 0.66482539 0 1.88351863e-05)
    list(2.24825e-09 0.664825378 0 1.86453464e-05)
    list(2.25025e-09 0.664825367 0 1.84583696e-05)
    list(2.25225e-09 0.664825356 0 1.82834597e-05)
    list(2.25425e-09 0.664825346 0 1.81296531e-05)
    list(2.25625e-09 0.664825337 0 1.80012358e-05)
    list(2.25825e-09 0.664825328 0 1.78979311e-05)
    list(2.26025e-09 0.66482532 0 1.78167789e-05)
    list(2.26225e-09 0.664825312 0 1.77538662e-05)
    list(2.26425e-09 0.664825304 0 1.77053529e-05)
    list(2.26625e-09 0.664825297 0 1.76679169e-05)
    list(2.26825e-09 0.66482529 0 1.76388696e-05)
    list(2.27025e-09 0.664825282 0 1.76161199e-05)
    list(2.27225e-09 0.664825275 0 1.75980809e-05)
    list(2.27425e-09 0.664825268 0 1.75835681e-05)
    list(2.27625e-09 0.664825261 0 1.75717057e-05)
    list(2.27825e-09 0.664825254 0 1.75618498e-05)
    list(2.28025e-09 0.664825247 0 1.75535279e-05)
    list(2.28225e-09 0.664825239 0 1.75463927e-05)
    list(2.28425e-09 0.664825232 0 1.75401884e-05)
    list(2.28625e-09 0.664825225 0 1.75347253e-05)
    list(2.28825e-09 0.664825218 0 1.75298616e-05)
    list(2.29025e-09 0.664825211 0 1.75254905e-05)
    list(2.29225e-09 0.664825204 0 1.75215305e-05)
    list(2.29425e-09 0.664825197 0 1.75179187e-05)
    list(2.29625e-09 0.66482519 0 1.75146057e-05)
    list(2.29825e-09 0.664825183 0 1.75115524e-05)
    list(2.3e-09 0.664825176 8.27180613e-14 1.75080786e-05)
    list(2.30075e-09 0.664817012 0.15 2.71088044e-05)
    list(2.30275e-09 0.664796638 0.55 6.35669587e-05)
    list(2.30475e-09 0.665087127 0.95 0.000112431754)
    list(2.30535e-09 0.66523628 1 6.87095046e-05)
    list(2.30725e-09 0.665660079 1 5.69651373e-05)
    list(2.30925e-09 0.666034251 1 5.19429803e-05)
    list(2.31125e-09 0.666376713 1 4.97067385e-05)
    list(2.31325e-09 0.666704682 1 4.86080135e-05)
    list(2.31525e-09 0.667025302 1 4.8003627e-05)
    list(2.31725e-09 0.667341729 1 4.76289255e-05)
    list(2.31925e-09 0.667655459 1 4.7369322e-05)
    list(2.32125e-09 0.667967264 1 4.71725255e-05)
    list(2.32325e-09 0.66827758 1 4.70131697e-05)
    list(2.32525e-09 0.668586679 1 4.68780489e-05)
    list(2.32725e-09 0.668894745 1 4.67597375e-05)
    list(2.32925e-09 0.66920191 1 4.66537333e-05)
    list(2.33015e-09 0.669346318 0.97 9.21929794e-06)
    list(2.33175e-09 0.669573099 0.65 -1.38611916e-05)
    list(2.33375e-09 0.669657002 0.25 -1.34043757e-05)
    list(2.33505e-09 0.669673654 0 2.21642663e-05)
    list(2.33625e-09 0.669673636 0 2.24347014e-05)
    list(2.33825e-09 0.669673614 0 2.05190985e-05)
    list(2.34025e-09 0.669673599 0 1.9665951e-05)
    list(2.34225e-09 0.669673585 0 1.92600005e-05)
    list(2.34425e-09 0.669673572 0 1.90145974e-05)
    list(2.34625e-09 0.66967356 0 1.88152763e-05)
    list(2.34825e-09 0.669673549 0 1.86236563e-05)
    list(2.35025e-09 0.669673537 0 1.84369153e-05)
    list(2.35225e-09 0.669673527 0 1.82639786e-05)
    list(2.35425e-09 0.669673517 0 1.81131144e-05)
    list(2.35625e-09 0.669673508 0 1.79878606e-05)
    list(2.35825e-09 0.669673499 0 1.78874587e-05)
    list(2.36025e-09 0.66967349 0 1.78087394e-05)
    list(2.36225e-09 0.669673482 0 1.7747757e-05)
    list(2.36425e-09 0.669673475 0 1.77007234e-05)
    list(2.36625e-09 0.669673467 0 1.76643963e-05)
    list(2.36825e-09 0.669673459 0 1.76361677e-05)
    list(2.37025e-09 0.669673452 0 1.76140162e-05)
    list(2.37225e-09 0.669673445 0 1.75964119e-05)
    list(2.37425e-09 0.669673437 0 1.7582214e-05)
    list(2.37625e-09 0.66967343 0 1.75705796e-05)
    list(2.37825e-09 0.669673423 0 1.75608893e-05)
    list(2.38025e-09 0.669673416 0 1.7552688e-05)
    list(2.38225e-09 0.669673408 0 1.75456416e-05)
    list(2.38425e-09 0.669673401 0 1.75395033e-05)
    list(2.38625e-09 0.669673394 0 1.753409e-05)
    list(2.38825e-09 0.669673387 0 1.75292645e-05)
    list(2.39025e-09 0.669673379 0 1.75249233e-05)
    list(2.39225e-09 0.669673372 0 1.75209873e-05)
    list(2.39425e-09 0.669673365 0 1.75173951e-05)
    list(2.39625e-09 0.669673358 0 1.75140988e-05)
    list(2.39825e-09 0.66967335 0 1.75110599e-05)
    list(2.4e-09 0.669673344 0 1.75076007e-05)
    list(2.40075e-09 0.669664984 0.15 2.71169993e-05)
    list(2.40275e-09 0.669643484 0.55 6.34512004e-05)
    list(2.40475e-09 0.669930779 0.95 0.000111652825)
    list(2.40535e-09 0.670077607 1 6.78565439e-05)
    list(2.40725e-09 0.67049542 1 5.63010384e-05)
    list(2.40925e-09 0.670864849 1 5.13911653e-05)
    list(2.41125e-09 0.671203461 1 4.9216665e-05)
    list(2.41325e-09 0.671528071 1 4.81522603e-05)
    list(2.41525e-09 0.671845606 1 4.75674033e-05)
    list(2.41725e-09 0.672159105 1 4.72042665e-05)
    list(2.41925e-09 0.672469998 1 4.6951946e-05)
    list(2.42125e-09 0.672779024 1 4.67600915e-05)
    list(2.42325e-09 0.673086599 1 4.66043469e-05)
    list(2.42525e-09 0.673392983 1 4.64720292e-05)
    list(2.42725e-09 0.673698353 1 4.63559905e-05)
    list(2.42925e-09 0.674002838 1 4.62518831e-05)
    list(2.43015e-09 0.674146128 0.97 8.89115419e-06)
    list(2.43175e-09 0.674374036 0.65 -1.39570553e-05)
    list(2.43375e-09 0.674459167 0.25 -1.34701945e-05)
    list(2.43505e-09 0.674476223 0 2.21662555e-05)
    list(2.43625e-09 0.674476204 0 2.24308116e-05)
    list(2.43825e-09 0.674476183 0 2.05101303e-05)
    list(2.44025e-09 0.674476167 0 1.96543266e-05)
    list(2.44225e-09 0.674476153 0 1.92458989e-05)
    list(2.44425e-09 0.67447614 0 1.89974119e-05)
    list(2.44625e-09 0.674476128 0 1.87950853e-05)
    list(2.44825e-09 0.674476116 0 1.86019072e-05)
    list(2.45025e-09 0.674476105 0 1.84156494e-05)
    list(2.45225e-09 0.674476095 0 1.82448605e-05)
    list(2.45425e-09 0.674476085 0 1.8097015e-05)
    list(2.45625e-09 0.674476075 0 1.79749257e-05)
    list(2.45825e-09 0.674476066 0 1.7877387e-05)
    list(2.46025e-09 0.674476058 0 1.78010472e-05)
    list(2.46225e-09 0.67447605 0 1.77419431e-05)
    list(2.46425e-09 0.674476042 0 1.76963444e-05)
    list(2.46625e-09 0.674476034 0 1.76610902e-05)
    list(2.46825e-09 0.674476027 0 1.76336523e-05)
    list(2.47025e-09 0.674476019 0 1.7612078e-05)
    list(2.47225e-09 0.674476012 0 1.75948926e-05)
    list(2.47425e-09 0.674476004 0 1.75809979e-05)
    list(2.47625e-09 0.674475997 0 1.75695829e-05)
    list(2.47825e-09 0.674475989 0 1.75600515e-05)
    list(2.48025e-09 0.674475982 0 1.75519662e-05)
    list(2.48225e-09 0.674475974 0 1.75450048e-05)
    list(2.48425e-09 0.674475967 0 1.75389295e-05)
    list(2.48625e-09 0.67447596 0 1.75335634e-05)
    list(2.48825e-09 0.674475952 0 1.75287741e-05)
    list(2.49025e-09 0.674475945 0 1.75244611e-05)
    list(2.49225e-09 0.674475937 0 1.75205474e-05)
    list(2.49425e-09 0.67447593 0 1.75169736e-05)
    list(2.49625e-09 0.674475923 0 1.75136925e-05)
    list(2.49825e-09 0.674475915 0 1.75106667e-05)
    list(2.5e-09 0.674475909 0 1.75072206e-05)
    list(2.50075e-09 0.674467353 0.15 2.71252053e-05)
    list(2.50275e-09 0.674444749 0.55 6.33353015e-05)
    list(2.50475e-09 0.674728783 0.95 0.000110858811)
    list(2.50535e-09 0.674873259 1 6.69963167e-05)
    list(2.50725e-09 0.675285064 1 5.56362395e-05)
    list(2.50925e-09 0.675649762 1 5.08407755e-05)
    list(2.51125e-09 0.675984544 1 4.87278686e-05)
    list(2.51325e-09 0.67630581 1 4.76970924e-05)
    list(2.51525e-09 0.676620268 1 4.71310839e-05)
    list(2.51725e-09 0.67693084 1 4.67789978e-05)
    list(2.51925e-09 0.677238895 1 4.65336079e-05)
    list(2.52125e-09 0.677545136 1 4.63464622e-05)
    list(2.52325e-09 0.677849962 1 4.6194171e-05)
    list(2.52525e-09 0.678153623 1 4.60645451e-05)
    list(2.52725e-09 0.678456289 1 4.5950696e-05)
    list(2.52925e-09 0.678758085 1 4.58484195e-05)
    list(2.53015e-09 0.678900248 0.97 8.55901845e-06)
    list(2.53175e-09 0.679129264 0.65 -1.40716931e-05)
    list(2.53375e-09 0.679215615 0.25 -1.35542126e-05)
    list(2.53505e-09 0.679233076 0 2.21681731e-05)
    list(2.53625e-09 0.679233057 0 2.2426921e-05)
    list(2.53825e-09 0.679233035 0 2.05011599e-05)
    list(2.54025e-09 0.679233019 0 1.96426146e-05)
    list(2.54225e-09 0.679233005 0 1.92315635e-05)
    list(2.54425e-09 0.679232992 0 1.89798906e-05)
    list(2.54625e-09 0.67923298 0 1.87746437e-05)
    list(2.54825e-09 0.679232968 0 1.85801418e-05)
    list(2.55025e-09 0.679232957 0 1.83946094e-05)
    list(2.55225e-09 0.679232947 0 1.82261294e-05)
    list(2.55425e-09 0.679232937 0 1.80813661e-05)
    list(2.55625e-09 0.679232927 0 1.79624327e-05)
    list(2.55825e-09 0.679232918 0 1.7867712e-05)
    list(2.56025e-09 0.67923291 0 1.77936959e-05)
    list(2.56225e-09 0.679232901 0 1.77364169e-05)
    list(2.56425e-09 0.679232893 0 1.76922079e-05)
    list(2.56625e-09 0.679232886 0 1.76579904e-05)
    list(2.56825e-09 0.679232878 0 1.76313153e-05)
    list(2.57025e-09 0.67923287 0 1.76102972e-05)
    list(2.57225e-09 0.679232862 0 1.75935151e-05)
    list(2.57425e-09 0.679232855 0 1.75799118e-05)
    list(2.57625e-09 0.679232847 0 1.75687076e-05)
    list(2.57825e-09 0.67923284 0 1.75593289e-05)
    list(2.58025e-09 0.679232832 0 1.75513545e-05)
    list(2.58225e-09 0.679232825 0 1.75444744e-05)
    list(2.58425e-09 0.679232817 0 1.75384592e-05)
    list(2.58625e-09 0.67923281 0 1.7533138e-05)
    list(2.58825e-09 0.679232802 0 1.75283828e-05)
    list(2.59025e-09 0.679232794 0 1.75240962e-05)
    list(2.59225e-09 0.679232787 0 1.75202034e-05)
    list(2.59425e-09 0.679232779 0 1.75166464e-05)
    list(2.59625e-09 0.679232772 0 1.75133793e-05)
    list(2.59825e-09 0.679232764 0 1.75103653e-05)
    list(2.6e-09 0.679232758 0 1.75069309e-05)
    list(2.60075e-09 0.679224005 0.15 2.71334245e-05)
    list(2.60275e-09 0.679200319 0.55 6.32192255e-05)
    list(2.60475e-09 0.679481026 0.95 0.000110049829)
    list(2.60535e-09 0.679623123 1 6.61291756e-05)
    list(2.60725e-09 0.680028899 1 5.49710391e-05)
    list(2.60925e-09 0.680388886 1 5.02918704e-05)
    list(2.61125e-09 0.680719856 1 4.82402126e-05)
    list(2.61325e-09 0.681037791 1 4.7242295e-05)
    list(2.61525e-09 0.681349179 1 4.66944434e-05)
    list(2.61725e-09 0.681656824 1 4.63529069e-05)
    list(2.61925e-09 0.681962036 1 4.61141139e-05)
    list(2.62125e-09 0.682265486 1 4.59314593e-05)
    list(2.62325e-09 0.682567556 1 4.57824766e-05)
    list(2.62525e-09 0.682868484 1 4.56554412e-05)
    list(2.62725e-09 0.683168436 1 4.55437064e-05)
    list(2.62925e-09 0.683467532 1 4.54432018e-05)
    list(2.63015e-09 0.683608562 0.97 8.2229671e-06)
    list(2.63175e-09 0.683838662 0.65 -1.42038135e-05)
    list(2.63375e-09 0.683926229 0.25 -1.36545804e-05)
    list(2.63505e-09 0.683944094 0 2.21700345e-05)
    list(2.63625e-09 0.683944075 0 2.24230351e-05)
    list(2.63825e-09 0.683944052 0 2.04921851e-05)
    list(2.64025e-09 0.683944036 0 1.96308029e-05)
    list(2.64225e-09 0.683944022 0 1.92169774e-05)
    list(2.64425e-09 0.68394401 0 1.89620327e-05)
    list(2.64625e-09 0.683943997 0 1.87539754e-05)
    list(2.64825e-09 0.683943985 0 1.85583926e-05)
    list(2.65025e-09 0.683943974 0 1.83738212e-05)
    list(2.65225e-09 0.683943964 0 1.82077981e-05)
    list(2.65425e-09 0.683943954 0 1.80661681e-05)
    list(2.65625e-09 0.683943944 0 1.7950374e-05)
    list(2.65825e-09 0.683943935 0 1.7858422e-05)
    list(2.66025e-09 0.683943927 0 1.7786672e-05)
    list(2.66225e-09 0.683943918 0 1.77311645e-05)
    list(2.66425e-09 0.68394391 0 1.76883003e-05)
    list(2.66625e-09 0.683943902 0 1.76550837e-05)
    list(2.66825e-09 0.683943894 0 1.76291439e-05)
    list(2.67025e-09 0.683943886 0 1.76086612e-05)
    list(2.67225e-09 0.683943879 0 1.75922668e-05)
    list(2.67425e-09 0.683943871 0 1.75789437e-05)
    list(2.67625e-09 0.683943863 0 1.75679417e-05)
    list(2.67825e-09 0.683943855 0 1.75587093e-05)
    list(2.68025e-09 0.683943848 0 1.75508412e-05)
    list(2.68225e-09 0.68394384 0 1.75440386e-05)
    list(2.68425e-09 0.683943832 0 1.75380806e-05)
    list(2.68625e-09 0.683943825 0 1.75328021e-05)
    list(2.68825e-09 0.683943817 0 1.7528079e-05)
    list(2.69025e-09 0.683943809 0 1.75238171e-05)
    list(2.69225e-09 0.683943802 0 1.75199438e-05)
    list(2.69425e-09 0.683943794 0 1.75164023e-05)
    list(2.69625e-09 0.683943786 0 1.75131479e-05)
    list(2.69825e-09 0.683943779 0 1.75101446e-05)
    list(2.7e-09 0.683943772 0 1.75067204e-05)
    list(2.70075e-09 0.683934822 0.15 2.71416582e-05)
    list(2.70275e-09 0.683910075 0.55 6.31029334e-05)
    list(2.70475e-09 0.684187388 0.95 0.000109226006)
    list(2.70535e-09 0.68432708 1 6.52555502e-05)
    list(2.70725e-09 0.684726812 1 5.43057587e-05)
    list(2.70925e-09 0.685082101 1 4.97443e-05)
    list(2.71125e-09 0.685409277 1 4.77534757e-05)
    list(2.71325e-09 0.685723893 1 4.67876319e-05)
    list(2.71525e-09 0.686032214 1 4.62572613e-05)
    list(2.71725e-09 0.686336931 1 4.59257988e-05)
    list(2.71925e-09 0.686639296 1 4.56932935e-05)
    list(2.72125e-09 0.686939948 1 4.55149326e-05)
    list(2.72325e-09 0.687239251 1 4.5369129e-05)
    list(2.72525e-09 0.687537437 1 4.52445951e-05)
    list(2.72725e-09 0.687834664 1 4.51349093e-05)
    list(2.72925e-09 0.68813105 1 4.50361252e-05)
    list(2.73015e-09 0.688270939 0.97 7.88311856e-06)
    list(2.73175e-09 0.688502097 0.65 -1.4351642e-05)
    list(2.73375e-09 0.688590876 0.25 -1.37688893e-05)
    list(2.73505e-09 0.688609145 0 2.21718551e-05)
    list(2.73625e-09 0.688609126 0 2.24191583e-05)
    list(2.73825e-09 0.688609103 0 2.0483202e-05)
    list(2.74025e-09 0.688609087 0 1.96188771e-05)
    list(2.74225e-09 0.688609073 0 1.9202123e-05)
    list(2.74425e-09 0.68860906 0 1.89438394e-05)
    list(2.74625e-09 0.688609048 0 1.87331052e-05)
    list(2.74825e-09 0.688609036 0 1.85366908e-05)
    list(2.75025e-09 0.688609025 0 1.83533073e-05)
    list(2.75225e-09 0.688609014 0 1.81898753e-05)
    list(2.75425e-09 0.688609004 0 1.80514176e-05)
    list(2.75625e-09 0.688608994 0 1.79387385e-05)
    list(2.75825e-09 0.688608985 0 1.78495021e-05)
    list(2.76025e-09 0.688608977 0 1.77799592e-05)
    list(2.76225e-09 0.688608968 0 1.77261693e-05)
    list(2.76425e-09 0.68860896 0 1.76846048e-05)
    list(2.76625e-09 0.688608952 0 1.76523537e-05)
    list(2.76825e-09 0.688608944 0 1.76271219e-05)
    list(2.77025e-09 0.688608936 0 1.76071542e-05)
    list(2.77225e-09 0.688608928 0 1.75911324e-05)
    list(2.77425e-09 0.68860892 0 1.75780782e-05)
    list(2.77625e-09 0.688608912 0 1.756727e-05)
    list(2.77825e-09 0.688608904 0 1.75581777e-05)
    list(2.78025e-09 0.688608897 0 1.75504111e-05)
    list(2.78225e-09 0.688608889 0 1.75436826e-05)
    list(2.78425e-09 0.688608881 0 1.7537779e-05)
    list(2.78625e-09 0.688608873 0 1.75325408e-05)
    list(2.78825e-09 0.688608865 0 1.75278481e-05)
    list(2.79025e-09 0.688608857 0 1.75236094e-05)
    list(2.79225e-09 0.68860885 0 1.75197541e-05)
    list(2.79425e-09 0.688608842 0 1.7516227e-05)
    list(2.79625e-09 0.688608834 0 1.75129842e-05)
    list(2.79825e-09 0.688608826 0 1.75099905e-05)
    list(2.8e-09 0.688608819 0 1.75065755e-05)
    list(2.80075e-09 0.688599671 0.15 2.71499065e-05)
    list(2.80275e-09 0.688573886 0.55 6.29863846e-05)
    list(2.80475e-09 0.688847737 0.95 0.00010838749)
    list(2.80535e-09 0.688984998 1 6.43759438e-05)
    list(2.80725e-09 0.689378672 1 5.3639259e-05)
    list(2.80925e-09 0.689729276 1 4.91979707e-05)
    list(2.81125e-09 0.690052676 1 4.72675312e-05)
    list(2.81325e-09 0.690363982 1 4.63329732e-05)
    list(2.81525e-09 0.69066924 1 4.58194236e-05)
    list(2.81725e-09 0.690971027 1 4.54975806e-05)
    list(2.81925e-09 0.691270539 1 4.52710723e-05)
    list(2.82125e-09 0.691568384 1 4.50968215e-05)
    list(2.82325e-09 0.691864913 1 4.49540777e-05)
    list(2.82525e-09 0.692160346 1 4.48319631e-05)
    list(2.82725e-09 0.692454837 1 4.47242658e-05)
    list(2.82925e-09 0.692748499 1 4.46271551e-05)
    list(2.83015e-09 0.69288724 0.97 7.53962104e-06)
    list(2.83175e-09 0.693119433 0.65 -1.45130043e-05)
    list(2.83375e-09 0.693209421 0.25 -1.3894273e-05)
    list(2.83505e-09 0.693228093 0 2.21736547e-05)
    list(2.83625e-09 0.693228074 0 2.24152955e-05)
    list(2.83825e-09 0.693228051 0 2.04742032e-05)
    list(2.84025e-09 0.693228035 0 1.96068181e-05)
    list(2.84225e-09 0.693228021 0 1.91869795e-05)
    list(2.84425e-09 0.693228007 0 1.89253104e-05)
    list(2.84625e-09 0.693227995 0 1.87120546e-05)
    list(2.84825e-09 0.693227983 0 1.85150618e-05)
    list(2.85025e-09 0.693227972 0 1.83330833e-05)
    list(2.85225e-09 0.693227961 0 1.81723628e-05)
    list(2.85425e-09 0.693227951 0 1.80371051e-05)
    list(2.85625e-09 0.693227942 0 1.79275099e-05)
    list(2.85825e-09 0.693227932 0 1.7840933e-05)
    list(2.86025e-09 0.693227924 0 1.77735371e-05)
    list(2.86225e-09 0.693227915 0 1.77214108e-05)
    list(2.86425e-09 0.693227907 0 1.76811017e-05)
    list(2.86625e-09 0.693227899 0 1.7649781e-05)
    list(2.86825e-09 0.69322789 0 1.76252305e-05)
    list(2.87025e-09 0.693227882 0 1.76057577e-05)
    list(2.87225e-09 0.693227874 0 1.75900936e-05)
    list(2.87425e-09 0.693227866 0 1.75772971e-05)
    list(2.87625e-09 0.693227858 0 1.75666748e-05)
    list(2.87825e-09 0.69322785 0 1.75577165e-05)
    list(2.88025e-09 0.693227842 0 1.75500469e-05)
    list(2.88225e-09 0.693227834 0 1.7543389e-05)
    list(2.88425e-09 0.693227826 0 1.75375371e-05)
    list(2.88625e-09 0.693227818 0 1.75323372e-05)
    list(2.88825e-09 0.69322781 0 1.75276732e-05)
    list(2.89025e-09 0.693227803 0 1.75234563e-05)
    list(2.89225e-09 0.693227795 0 1.75196178e-05)
    list(2.89425e-09 0.693227787 0 1.75161039e-05)
    list(2.89625e-09 0.693227779 0 1.75128718e-05)
    list(2.89825e-09 0.693227771 0 1.7509887e-05)
    list(2.9e-09 0.693227764 8.27180613e-14 1.750648e-05)
    list(2.90075e-09 0.693218416 0.15 2.71581685e-05)
    list(2.90275e-09 0.693191614 0.55 6.28695363e-05)
    list(2.90475e-09 0.693461935 0.95 0.000107534447)
    list(2.90535e-09 0.693596741 1 6.34909242e-05)
    list(2.90725e-09 0.693984351 1 5.29749128e-05)
    list(2.90925e-09 0.694330295 1 4.86533329e-05)
    list(2.91125e-09 0.694649938 1 4.67824406e-05)
    list(2.91325e-09 0.694957946 1 4.58782519e-05)
    list(2.91525e-09 0.695260143 1 4.53808366e-05)
    list(2.91725e-09 0.695558998 1 4.50681657e-05)
    list(2.91925e-09 0.69585565 1 4.48473787e-05)
    list(2.92125e-09 0.696150681 1 4.46770684e-05)
    list(2.92325e-09 0.696444424 1 4.45372764e-05)
    list(2.92525e-09 0.696737094 1 4.44175079e-05)
    list(2.92725e-09 0.697028838 1 4.4311746e-05)
    list(2.92925e-09 0.697319766 1 4.42162675e-05)
    list(2.93015e-09 0.697457352 0.97 7.19222211e-06)
    list(2.93175e-09 0.69769055 0.65 -1.46854957e-05)
    list(2.93375e-09 0.697781745 0.25 -1.40276212e-05)
    list(2.93505e-09 0.697800821 0 2.21754286e-05)
    list(2.93625e-09 0.697800801 0 2.24114359e-05)
    list(2.93825e-09 0.697800778 0 2.04651737e-05)
    list(2.94025e-09 0.697800762 0 1.95946024e-05)
    list(2.94225e-09 0.697800748 0 1.9171526e-05)
    list(2.94425e-09 0.697800735 0 1.89064484e-05)
    list(2.94625e-09 0.697800722 0 1.86908465e-05)
    list(2.94825e-09 0.69780071 0 1.84935299e-05)
    list(2.95025e-09 0.697800699 0 1.83131628e-05)
    list(2.95225e-09 0.697800688 0 1.81552602e-05)
    list(2.95425e-09 0.697800678 0 1.80232192e-05)
    list(2.95625e-09 0.697800669 0 1.79166704e-05)
    list(2.95825e-09 0.697800659 0 1.78326939e-05)
    list(2.96025e-09 0.69780065 0 1.7767384e-05)
    list(2.96225e-09 0.697800642 0 1.77168676e-05)
    list(2.96425e-09 0.697800633 0 1.76777697e-05)
    list(2.96625e-09 0.697800625 0 1.76473449e-05)
    list(2.96825e-09 0.697800617 0 1.76234494e-05)
    list(2.97025e-09 0.697800608 0 1.76044518e-05)
    list(2.97225e-09 0.6978006 0 1.75891307e-05)
    list(2.97425e-09 0.697800592 0 1.75765814e-05)
    list(2.97625e-09 0.697800584 0 1.75661368e-05)
    list(2.97825e-09 0.697800576 0 1.75573067e-05)
    list(2.98025e-09 0.697800568 0 1.75497298e-05)
    list(2.98225e-09 0.69780056 0 1.75431392e-05)
    list(2.98425e-09 0.697800552 0 1.75373365e-05)
    list(2.98625e-09 0.697800543 0 1.7532173e-05)
    list(2.98825e-09 0.697800535 0 1.75275361e-05)
    list(2.99025e-09 0.697800527 0 1.75233397e-05)
    list(2.99225e-09 0.697800519 0 1.7519517e-05)
    list(2.99425e-09 0.697800511 0 1.75160155e-05)
    list(2.99625e-09 0.697800503 0 1.75127933e-05)
    list(2.99825e-09 0.697800495 0 1.75098166e-05)
    list(3e-09 0.697800488 0 1.75064171e-05)
    list(3.00075e-09 0.697790941 0.15 2.7166442e-05)
    list(3.00275e-09 0.697763143 0.55 6.27523439e-05)
    list(3.00475e-09 0.698029864 0.95 0.000106667065)
    list(3.00535e-09 0.698162194 1 6.26011168e-05)
    list(3.00725e-09 0.698543741 1 5.23117128e-05)
    list(3.00925e-09 0.698885046 1 4.81103226e-05)
    list(3.01125e-09 0.69920095 1 4.6298137e-05)
    list(3.01325e-09 0.699505669 1 4.54234158e-05)
    list(3.01525e-09 0.699804807 1 4.49414715e-05)
    list(3.01725e-09 0.700100727 1 4.46375475e-05)
    list(3.01925e-09 0.700394513 1 4.44222225e-05)
    list(3.02125e-09 0.700686721 1 4.42556942e-05)
    list(3.02325e-09 0.70097767 1 4.41187529e-05)
    list(3.02525e-09 0.701267566 1 4.40012618e-05)
    list(3.02725e-09 0.701556551 1 4.3897385e-05)
    list(3.02925e-09 0.701844734 1 4.38034998e-05)
    list(3.03015e-09 0.701981159 0.97 6.84197329e-06)
    list(3.03175e-09 0.702215332 0.65 -1.48666544e-05)
    list(3.03375e-09 0.702307733 0.25 -1.41656892e-05)
    list(3.03505e-09 0.702327212 0 2.21771974e-05)
    list(3.03625e-09 0.702327192 0 2.24075838e-05)
    list(3.03825e-09 0.702327169 0 2.04561046e-05)
    list(3.04025e-09 0.702327152 0 1.958221e-05)
    list(3.04225e-09 0.702327138 0 1.91557459e-05)
    list(3.04425e-09 0.702327125 0 1.88872608e-05)
    list(3.04625e-09 0.702327113 0 1.86695062e-05)
    list(3.04825e-09 0.702327101 0 1.84721195e-05)
    list(3.05025e-09 0.702327089 0 1.82935576e-05)
    list(3.05225e-09 0.702327079 0 1.81385652e-05)
    list(3.05425e-09 0.702327068 0 1.80097469e-05)
    list(3.05625e-09 0.702327059 0 1.79062011e-05)
    list(3.05825e-09 0.702327049 0 1.78247632e-05)
    list(3.06025e-09 0.70232704 0 1.77614777e-05)
    list(3.06225e-09 0.702327032 0 1.77125173e-05)
    list(3.06425e-09 0.702327023 0 1.76745869e-05)
    list(3.06625e-09 0.702327015 0 1.7645024e-05)
    list(3.06825e-09 0.702327006 0 1.76217576e-05)
    list(3.07025e-09 0.702326998 0 1.76032158e-05)
    list(3.07225e-09 0.70232699 0 1.75882235e-05)
    list(3.07425e-09 0.702326981 0 1.75759107e-05)
    list(3.07625e-09 0.702326973 0 1.75656363e-05)
    list(3.07825e-09 0.702326965 0 1.75569286e-05)
    list(3.08025e-09 0.702326956 0 1.75494401e-05)
    list(3.08225e-09 0.702326948 0 1.75429137e-05)
    list(3.08425e-09 0.70232694 0 1.75371579e-05)
    list(3.08625e-09 0.702326932 0 1.75320289e-05)
    list(3.08825e-09 0.702326923 0 1.75274178e-05)
    list(3.09025e-09 0.702326915 0 1.75232408e-05)
    list(3.09225e-09 0.702326907 0 1.75194331e-05)
    list(3.09425e-09 0.702326899 0 1.75159432e-05)
    list(3.09625e-09 0.702326891 0 1.75127304e-05)
    list(3.09825e-09 0.702326882 0 1.75097612e-05)
    list(3.1e-09 0.702326875 0 1.75063686e-05)
    list(3.10075e-09 0.702317128 0.15 2.71747263e-05)
    list(3.10275e-09 0.702288356 0.55 6.26347612e-05)
    list(3.10475e-09 0.702551407 0.95 0.000105785541)
    list(3.10535e-09 0.70268124 1 6.17071799e-05)
    list(3.10725e-09 0.703056721 1 5.16496259e-05)
    list(3.10925e-09 0.703393409 1 4.75688341e-05)
    list(3.11125e-09 0.703705593 1 4.58144978e-05)
    list(3.11325e-09 0.704007031 1 4.49683603e-05)
    list(3.11525e-09 0.704303113 1 4.45012547e-05)
    list(3.11725e-09 0.704596094 1 4.42056817e-05)
    list(3.11925e-09 0.704887008 1 4.39955827e-05)
    list(3.12125e-09 0.705176385 1 4.38326949e-05)
    list(3.12325e-09 0.70546453 1 4.36985158e-05)
    list(3.12525e-09 0.705751641 1 4.35832426e-05)
    list(3.12725e-09 0.706037858 1 4.3481208e-05)
    list(3.12925e-09 0.706323283 1 4.3388883e-05)
    list(3.13015e-09 0.70645854 0.97 6.48866248e-06)
    list(3.13175e-09 0.706693658 0.65 -1.50539217e-05)
    list(3.13375e-09 0.706787265 0.25 -1.43051723e-05)
    list(3.13505e-09 0.706807146 0 2.21789667e-05)
    list(3.13625e-09 0.706807126 0 2.2403733e-05)
    list(3.13825e-09 0.706807103 0 2.04469792e-05)
    list(3.14025e-09 0.706807086 0 1.95696148e-05)
    list(3.14225e-09 0.706807071 0 1.91396206e-05)
    list(3.14425e-09 0.706807058 0 1.8867755e-05)
    list(3.14625e-09 0.706807046 0 1.86480569e-05)
    list(3.14825e-09 0.706807034 0 1.84508508e-05)
    list(3.15025e-09 0.706807022 0 1.82742752e-05)
    list(3.15225e-09 0.706807012 0 1.81222714e-05)
    list(3.15425e-09 0.706807001 0 1.79966723e-05)
    list(3.15625e-09 0.706806992 0 1.78960807e-05)
    list(3.15825e-09 0.706806982 0 1.78171178e-05)
    list(3.16025e-09 0.706806973 0 1.77557946e-05)
    list(3.16225e-09 0.706806964 0 1.77083369e-05)
    list(3.16425e-09 0.706806956 0 1.7671531e-05)
    list(3.16625e-09 0.706806947 0 1.76427964e-05)
    list(3.16825e-09 0.706806939 0 1.76201338e-05)
    list(3.17025e-09 0.70680693 0 1.7602029e-05)
    list(3.17225e-09 0.706806922 0 1.75873515e-05)
    list(3.17425e-09 0.706806913 0 1.7575265e-05)
    list(3.17625e-09 0.706806905 0 1.75651531e-05)
    list(3.17825e-09 0.706806896 0 1.75565624e-05)
    list(3.18025e-09 0.706806888 0 1.75491584e-05)
    list(3.18225e-09 0.70680688 0 1.75426932e-05)
    list(3.18425e-09 0.706806871 0 1.7536982e-05)
    list(3.18625e-09 0.706806863 0 1.7531886e-05)
    list(3.18825e-09 0.706806854 0 1.75272994e-05)
    list(3.19025e-09 0.706806846 0 1.7523141e-05)
    list(3.19225e-09 0.706806838 0 1.75193475e-05)
    list(3.19425e-09 0.706806829 0 1.75158688e-05)
    list(3.19625e-09 0.706806821 0 1.75126649e-05)
    list(3.19825e-09 0.706806812 0 1.7509703e-05)
    list(3.2e-09 0.706806805 0 1.75063171e-05)
    list(3.20075e-09 0.706796858 0.15 2.7183018e-05)
    list(3.20275e-09 0.706767131 0.55 6.25167406e-05)
    list(3.20475e-09 0.707026444 0.95 0.000104890115)
    list(3.20535e-09 0.70715376 1 6.08098265e-05)
    list(3.20725e-09 0.707523181 1 5.09891571e-05)
    list(3.20925e-09 0.707855277 1 4.70290305e-05)
    list(3.21125e-09 0.708163758 1 4.53315695e-05)
    list(3.21325e-09 0.708461925 1 4.45131083e-05)
    list(3.21525e-09 0.708754951 1 4.40602181e-05)
    list(3.21725e-09 0.70904499 1 4.37726157e-05)
    list(3.21925e-09 0.709333026 1 4.35675192e-05)
    list(3.22125e-09 0.709619563 1 4.34081389e-05)
    list(3.22325e-09 0.709904896 1 4.32766386e-05)
    list(3.22525e-09 0.710189213 1 4.31635273e-05)
    list(3.22725e-09 0.71047265 1 4.30632944e-05)
    list(3.22925e-09 0.710755307 1 4.29724983e-05)
    list(3.23015e-09 0.710889391 0.97 6.1325134e-06)
    list(3.23175e-09 0.711125419 0.65 -1.52448368e-05)
    list(3.23375e-09 0.711220234 0.25 -1.44428912e-05)
    list(3.23505e-09 0.711240516 0 2.21807404e-05)
    list(3.23625e-09 0.711240496 0 2.2399876e-05)
    list(3.23825e-09 0.711240472 0 2.04377794e-05)
    list(3.24025e-09 0.711240455 0 1.95567905e-05)
    list(3.24225e-09 0.711240441 0 1.91231348e-05)
    list(3.24425e-09 0.711240427 0 1.88479416e-05)
    list(3.24625e-09 0.711240415 0 1.86265223e-05)
    list(3.24825e-09 0.711240403 0 1.84297429e-05)
    list(3.25025e-09 0.711240391 0 1.82553214e-05)
    list(3.25225e-09 0.711240381 0 1.81063714e-05)
    list(3.25425e-09 0.71124037 0 1.79839786e-05)
    list(3.25625e-09 0.711240361 0 1.7886288e-05)
    list(3.25825e-09 0.711240351 0 1.78097347e-05)
    list(3.26025e-09 0.711240342 0 1.77503117e-05)
    list(3.26225e-09 0.711240333 0 1.77043037e-05)
    list(3.26425e-09 0.711240324 0 1.76685799e-05)
    list(3.26625e-09 0.711240315 0 1.7640641e-05)
    list(3.26825e-09 0.711240307 0 1.76185575e-05)
    list(3.27025e-09 0.711240298 0 1.76008712e-05)
    list(3.27225e-09 0.71124029 0 1.75864949e-05)
    list(3.27425e-09 0.711240281 0 1.75746247e-05)
    list(3.27625e-09 0.711240273 0 1.75646683e-05)
    list(3.27825e-09 0.711240264 0 1.75561893e-05)
    list(3.28025e-09 0.711240255 0 1.75488659e-05)
    list(3.28225e-09 0.711240247 0 1.75424591e-05)
    list(3.28425e-09 0.711240238 0 1.75367907e-05)
    list(3.28625e-09 0.71124023 0 1.75317261e-05)
    list(3.28825e-09 0.711240221 0 1.7527163e-05)
    list(3.29025e-09 0.711240213 0 1.75230224e-05)
    list(3.29225e-09 0.711240204 0 1.75192427e-05)
    list(3.29425e-09 0.711240196 0 1.75157749e-05)
    list(3.29625e-09 0.711240187 0 1.75125796e-05)
    list(3.29825e-09 0.711240179 0 1.7509625e-05)
    list(3.3e-09 0.711240171 0 1.75062458e-05)
    list(3.30075e-09 0.711230023 0.15 2.7191314e-05)
    list(3.30275e-09 0.711199363 0.55 6.23982329e-05)
    list(3.30475e-09 0.711454867 0.95 0.000103981058)
    list(3.30535e-09 0.71157965 1 5.99097913e-05)
    list(3.30725e-09 0.711943012 1 5.03302651e-05)
    list(3.30925e-09 0.712270541 1 4.64910264e-05)
    list(3.31125e-09 0.712575337 1 4.4849404e-05)
    list(3.31325e-09 0.712870242 1 4.40577085e-05)
    list(3.31525e-09 0.713160214 1 4.3618426e-05)
    list(3.31725e-09 0.713447308 1 4.33384296e-05)
    list(3.31925e-09 0.713732459 1 4.31381238e-05)
    list(3.32125e-09 0.71401615 1 4.29821253e-05)
    list(3.32325e-09 0.71429866 1 4.28532248e-05)
    list(3.32525e-09 0.714580174 1 4.27422218e-05)
    list(3.32725e-09 0.714860822 1 4.26437514e-05)
    list(3.32925e-09 0.715140701 1 4.25544539e-05)
    list(3.33015e-09 0.715273605 0.97 5.77375716e-06)
    list(3.33175e-09 0.715510511 0.65 -1.5437083e-05)
    list(3.33375e-09 0.715606533 0.25 -1.45758639e-05)
    list(3.33505e-09 0.715627217 0 2.21825269e-05)
    list(3.33625e-09 0.715627196 0 2.23960078e-05)
    list(3.33825e-09 0.715627172 0 2.04284871e-05)
    list(3.34025e-09 0.715627155 0 1.95437113e-05)
    list(3.34225e-09 0.71562714 0 1.91062762e-05)
    list(3.34425e-09 0.715627127 0 1.88278346e-05)
    list(3.34625e-09 0.715627114 0 1.86049275e-05)
    list(3.34825e-09 0.715627102 0 1.84088144e-05)
    list(3.35025e-09 0.715627091 0 1.82367007e-05)
    list(3.35225e-09 0.71562708 0 1.80908567e-05)
    list(3.35425e-09 0.71562707 0 1.7971649e-05)
    list(3.35625e-09 0.71562706 0 1.78768021e-05)
    list(3.35825e-09 0.71562705 0 1.78025918e-05)
    list(3.36025e-09 0.715627041 0 1.7745007e-05)
    list(3.36225e-09 0.715627032 0 1.77003965e-05)
    list(3.36425e-09 0.715627023 0 1.76657131e-05)
    list(3.36625e-09 0.715627014 0 1.76385378e-05)
    list(3.36825e-09 0.715627005 0 1.76170092e-05)
    list(3.37025e-09 0.715626997 0 1.75997235e-05)
    list(3.37225e-09 0.715626988 0 1.75856353e-05)
    list(3.37425e-09 0.715626979 0 1.75739719e-05)
    list(3.37625e-09 0.71562697 0 1.75641639e-05)
    list(3.37825e-09 0.715626962 0 1.75557916e-05)
    list(3.38025e-09 0.715626953 0 1.75485451e-05)
    list(3.38225e-09 0.715626944 0 1.75421943e-05)
    list(3.38425e-09 0.715626936 0 1.75365667e-05)
    list(3.38625e-09 0.715626927 0 1.75315324e-05)
    list(3.38825e-09 0.715626918 0 1.75269919e-05)
    list(3.39025e-09 0.71562691 0 1.75228686e-05)
    list(3.39225e-09 0.715626901 0 1.75191023e-05)
    list(3.39425e-09 0.715626892 0 1.75156452e-05)
    list(3.39625e-09 0.715626884 0 1.75124587e-05)
    list(3.39825e-09 0.715626875 0 1.75095113e-05)
    list(3.4e-09 0.715626868 0 1.7506139e-05)
    list(3.40075e-09 0.715616518 0.15 2.7199611e-05)
    list(3.40275e-09 0.715584945 0.55 6.22791877e-05)
    list(3.40475e-09 0.71583657 0.95 0.000103058683)
    list(3.40535e-09 0.715958804 1 5.90078288e-05)
    list(3.40725e-09 0.716316131 1 4.96739969e-05)
    list(3.40925e-09 0.71663912 1 4.59548569e-05)
    list(3.41125e-09 0.716940251 1 4.43679623e-05)
    list(3.41325e-09 0.717231902 1 4.3602124e-05)
    list(3.41525e-09 0.717518821 1 4.31758666e-05)
    list(3.41725e-09 0.717802967 1 4.29031371e-05)
    list(3.41925e-09 0.718085229 1 4.27074293e-05)
    list(3.42125e-09 0.718366065 1 4.25547008e-05)
    list(3.42325e-09 0.718645746 1 4.2428331e-05)
    list(3.42525e-09 0.718924448 1 4.23193901e-05)
    list(3.42725e-09 0.719202297 1 4.22226488e-05)
    list(3.42925e-09 0.719479389 1 4.21348243e-05)
    list(3.43015e-09 0.719611108 0.97 5.41263617e-06)
    list(3.43175e-09 0.719848855 0.65 -1.56285475e-05)
    list(3.43375e-09 0.719946089 0.25 -1.47014464e-05)
    list(3.43505e-09 0.719967171 0 2.21843097e-05)
    list(3.43625e-09 0.71996715 0 2.23921077e-05)
    list(3.43825e-09 0.719967126 0 2.04190757e-05)
    list(3.44025e-09 0.719967108 0 1.9530348e-05)
    list(3.44225e-09 0.719967094 0 1.9089034e-05)
    list(3.44425e-09 0.71996708 0 1.8807449e-05)
    list(3.44625e-09 0.719967068 0 1.85832961e-05)
    list(3.44825e-09 0.719967056 0 1.83880813e-05)
    list(3.45025e-09 0.719967044 0 1.82184155e-05)
    list(3.45225e-09 0.719967033 0 1.80757176e-05)
    list(3.45425e-09 0.719967023 0 1.79596663e-05)
    list(3.45625e-09 0.719967013 0 1.78676025e-05)
    list(3.45825e-09 0.719967003 0 1.77956679e-05)
    list(3.46025e-09 0.719966994 0 1.77398596e-05)
    list(3.46225e-09 0.719966985 0 1.76965952e-05)
    list(3.46425e-09 0.719966976 0 1.76629116e-05)
    list(3.46625e-09 0.719966967 0 1.76364686e-05)
    list(3.46825e-09 0.719966958 0 1.76154714e-05)
    list(3.47025e-09 0.719966949 0 1.7598569e-05)
    list(3.47225e-09 0.71996694 0 1.75847562e-05)
    list(3.47425e-09 0.719966931 0 1.75732904e-05)
    list(3.47625e-09 0.719966922 0 1.7563624e-05)
    list(3.47825e-09 0.719966914 0 1.75553537e-05)
    list(3.48025e-09 0.719966905 0 1.75481809e-05)
    list(3.48225e-09 0.719966896 0 1.75418835e-05)
    list(3.48425e-09 0.719966887 0 1.75362952e-05)
    list(3.48625e-09 0.719966878 0 1.753129e-05)
    list(3.48825e-09 0.71996687 0 1.75267715e-05)
    list(3.49025e-09 0.719966861 0 1.75226651e-05)
    list(3.49225e-09 0.719966852 0 1.75189121e-05)
    list(3.49425e-09 0.719966843 0 1.75154656e-05)
    list(3.49625e-09 0.719966834 0 1.7512288e-05)
    list(3.49825e-09 0.719966826 0 1.75093481e-05)
    list(3.5e-09 0.719966818 0 1.75059831e-05)
    list(3.50075e-09 0.719956266 0.15 2.72079054e-05)
    list(3.50275e-09 0.7199238 0.55 6.21595526e-05)
    list(3.50475e-09 0.720171477 0.95 0.000102123352)
    list(3.50535e-09 0.72029115 1 5.81046969e-05)
    list(3.50725e-09 0.720642459 1 4.90202624e-05)
    list(3.50925e-09 0.720960937 1 4.54206472e-05)
    list(3.51125e-09 0.721258421 1 4.38873262e-05)
    list(3.51325e-09 0.721546827 1 4.31464425e-05)
    list(3.51525e-09 0.721830696 1 4.27326446e-05)
    list(3.51725e-09 0.722111891 1 4.24668573e-05)
    list(3.51925e-09 0.722391258 1 4.22755645e-05)
    list(3.52125e-09 0.722669234 1 4.2125999e-05)
    list(3.52325e-09 0.722946078 1 4.20020933e-05)
    list(3.52525e-09 0.723221959 1 4.18951694e-05)
    list(3.52725e-09 0.723497002 1 4.18001241e-05)
    list(3.52925e-09 0.723771298 1 4.17137471e-05)
    list(3.53015e-09 0.723901827 0.97 5.04938982e-06)
    list(3.53175e-09 0.724140384 0.65 -1.58173082e-05)
    list(3.53375e-09 0.72423883 0.25 -1.48173374e-05)
    list(3.53505e-09 0.72426031 0 2.21860776e-05)
    list(3.53625e-09 0.724260289 0 2.23881549e-05)
    list(3.53825e-09 0.724260264 0 2.04095133e-05)
    list(3.54025e-09 0.724260247 0 1.95166654e-05)
    list(3.54225e-09 0.724260232 0 1.90713921e-05)
    list(3.54425e-09 0.724260219 0 1.87867928e-05)
    list(3.54625e-09 0.724260206 0 1.85616421e-05)
    list(3.54825e-09 0.724260194 0 1.83675493e-05)
    list(3.55025e-09 0.724260182 0 1.82004591e-05)
    list(3.55225e-09 0.724260172 0 1.80609372e-05)
    list(3.55425e-09 0.724260161 0 1.79480087e-05)
    list(3.55625e-09 0.724260151 0 1.78586659e-05)
    list(3.55825e-09 0.724260141 0 1.77889404e-05)
    list(3.56025e-09 0.724260132 0 1.77348485e-05)
    list(3.56225e-09 0.724260123 0 1.76928804e-05)
    list(3.56425e-09 0.724260113 0 1.76601572e-05)
    list(3.56625e-09 0.724260104 0 1.76344166e-05)
    list(3.56825e-09 0.724260095 0 1.76139283e-05)
    list(3.57025e-09 0.724260086 0 1.75973926e-05)
    list(3.57225e-09 0.724260077 0 1.7583843e-05)
    list(3.57425e-09 0.724260068 0 1.75725659e-05)
    list(3.57625e-09 0.724260059 0 1.7563035e-05)
    list(3.57825e-09 0.72426005 0 1.75548622e-05)
    list(3.58025e-09 0.724260042 0 1.75477598e-05)
    list(3.58225e-09 0.724260033 0 1.75415137e-05)
    list(3.58425e-09 0.724260024 0 1.75359632e-05)
    list(3.58625e-09 0.724260015 0 1.75309862e-05)
    list(3.58825e-09 0.724260006 0 1.75264893e-05)
    list(3.59025e-09 0.724259997 0 1.75223995e-05)
    list(3.59225e-09 0.724259988 0 1.75186598e-05)
    list(3.59425e-09 0.724259979 0 1.75152242e-05)
    list(3.59625e-09 0.72425997 0 1.75120557e-05)
    list(3.59825e-09 0.724259961 0 1.75091237e-05)
    list(3.6e-09 0.724259953 8.27180613e-14 1.75057667e-05)
    list(3.60075e-09 0.7242492 0.15 2.72161936e-05)
    list(3.60275e-09 0.72421586 0.55 6.20392735e-05)
    list(3.60475e-09 0.724459518 0.95 0.000101175487)
    list(3.60535e-09 0.72457662 1 5.72011516e-05)
    list(3.60725e-09 0.724921938 1 4.83694426e-05)
    list(3.60925e-09 0.725235934 1 4.48885516e-05)
    list(3.61125e-09 0.72552979 1 4.34075897e-05)
    list(3.61325e-09 0.72581496 1 4.26907583e-05)
    list(3.61525e-09 0.726095781 1 4.228887e-05)
    list(3.61725e-09 0.726374023 1 4.20297139e-05)
    list(3.61925e-09 0.726650491 1 4.18426615e-05)
    list(3.62125e-09 0.726925601 1 4.16961571e-05)
    list(3.62325e-09 0.727199601 1 4.1574651e-05)
    list(3.62525e-09 0.727472655 1 4.14696996e-05)
    list(3.62725e-09 0.727744883 1 4.13763176e-05)
    list(3.62925e-09 0.728016375 1 4.12913624e-05)
    list(3.63015e-09 0.728145711 0.97 4.68426015e-06)
    list(3.63175e-09 0.728385035 0.65 -1.60018697e-05)
    list(3.63375e-09 0.728484697 0.25 -1.49216412e-05)
    list(3.63505e-09 0.728506574 0 2.21878514e-05)
    list(3.63625e-09 0.728506552 0 2.23841594e-05)
    list(3.63825e-09 0.728506527 0 2.03997958e-05)
    list(3.64025e-09 0.72850651 0 1.9502659e-05)
    list(3.64225e-09 0.728506495 0 1.90533709e-05)
    list(3.64425e-09 0.728506481 0 1.87659109e-05)
    list(3.64625e-09 0.728506469 0 1.85400146e-05)
    list(3.64825e-09 0.728506456 0 1.83472559e-05)
    list(3.65025e-09 0.728506445 0 1.8182852e-05)
    list(3.65225e-09 0.728506434 0 1.80465219e-05)
    list(3.65425e-09 0.728506423 0 1.79366728e-05)
    list(3.65625e-09 0.728506413 0 1.78499842e-05)
    list(3.65825e-09 0.728506404 0 1.77823986e-05)
    list(3.66025e-09 0.728506394 0 1.7729962e-05)
    list(3.66225e-09 0.728506385 0 1.76892401e-05)
    list(3.66425e-09 0.728506375 0 1.76574382e-05)
    list(3.66625e-09 0.728506366 0 1.763237e-05)
    list(3.66825e-09 0.728506357 0 1.76123685e-05)
    list(3.67025e-09 0.728506348 0 1.7596183e-05)
    list(3.67225e-09 0.728506339 0 1.75828848e-05)
    list(3.67425e-09 0.72850633 0 1.75717878e-05)
    list(3.67625e-09 0.728506321 0 1.75623862e-05)
    list(3.67825e-09 0.728506311 0 1.75543065e-05)
    list(3.68025e-09 0.728506302 0 1.75472715e-05)
    list(3.68225e-09 0.728506293 0 1.75410748e-05)
    list(3.68425e-09 0.728506284 0 1.75355608e-05)
    list(3.68625e-09 0.728506275 0 1.75306112e-05)
    list(3.68825e-09 0.728506266 0 1.75261353e-05)
    list(3.69025e-09 0.728506257 0 1.75220622e-05)
    list(3.69225e-09 0.728506248 0 1.75183358e-05)
    list(3.69425e-09 0.728506239 0 1.75149114e-05)
    list(3.69625e-09 0.72850623 0 1.75117524e-05)
    list(3.69825e-09 0.728506221 0 1.75088289e-05)
    list(3.7e-09 0.728506213 0 1.75054807e-05)
    list(3.70075e-09 0.728495257 0.15 2.72244714e-05)
    list(3.70275e-09 0.728461062 0.55 6.19182948e-05)
    list(3.70475e-09 0.728700633 0.95 0.00010021559)
    list(3.70535e-09 0.728815156 1 5.62979414e-05)
    list(3.70725e-09 0.729154505 1 4.77216102e-05)
    list(3.70925e-09 0.72946405 1 4.43585728e-05)
    list(3.71125e-09 0.729754297 1 4.29287576e-05)
    list(3.71325e-09 0.73003624 1 4.22351048e-05)
    list(3.71525e-09 0.730314015 1 4.18446053e-05)
    list(3.71725e-09 0.730589303 1 4.15917915e-05)
    list(3.71925e-09 0.730862868 1 4.14088199e-05)
    list(3.72125e-09 0.731135107 1 4.12652841e-05)
    list(3.72325e-09 0.731406257 1 4.11461198e-05)
    list(3.72525e-09 0.731676478 1 4.10431014e-05)
    list(3.72725e-09 0.731945885 1 4.09513535e-05)
    list(3.72925e-09 0.732214566 1 4.08677976e-05)
    list(3.73015e-09 0.732342704 0.97 4.31749161e-06)
    list(3.73175e-09 0.732582758 0.65 -1.61808751e-05)
    list(3.73375e-09 0.732683639 0.25 -1.50129549e-05)
    list(3.73505e-09 0.73270591 0 2.21896071e-05)
    list(3.73625e-09 0.732705888 0 2.23800928e-05)
    list(3.73825e-09 0.732705863 0 2.0389887e-05)
    list(3.74025e-09 0.732705845 0 1.94882962e-05)
    list(3.74225e-09 0.73270583 0 1.90349627e-05)
    list(3.74425e-09 0.732705817 0 1.87448166e-05)
    list(3.74625e-09 0.732705804 0 1.85184284e-05)
    list(3.74825e-09 0.732705792 0 1.83272056e-05)
    list(3.75025e-09 0.73270578 0 1.81655867e-05)
    list(3.75225e-09 0.732705769 0 1.80324559e-05)
    list(3.75425e-09 0.732705758 0 1.79256395e-05)
    list(3.75625e-09 0.732705748 0 1.78415377e-05)
    list(3.75825e-09 0.732705738 0 1.77760243e-05)
    list(3.76025e-09 0.732705729 0 1.77251838e-05)
    list(3.76225e-09 0.732705719 0 1.76856599e-05)
    list(3.76425e-09 0.73270571 0 1.76547417e-05)
    list(3.76625e-09 0.7327057 0 1.76303174e-05)
    list(3.76825e-09 0.732705691 0 1.76107814e-05)
    list(3.77025e-09 0.732705682 0 1.75949306e-05)
    list(3.77225e-09 0.732705673 0 1.75818724e-05)
    list(3.77425e-09 0.732705663 0 1.75709474e-05)
    list(3.77625e-09 0.732705654 0 1.75616694e-05)
    list(3.77825e-09 0.732705645 0 1.75536787e-05)
    list(3.78025e-09 0.732705636 0 1.75467084e-05)
    list(3.78225e-09 0.732705626 0 1.75405592e-05)
    list(3.78425e-09 0.732705617 0 1.75350805e-05)
    list(3.78625e-09 0.732705608 0 1.75301578e-05)
    list(3.78825e-09 0.732705599 0 1.75257027e-05)
    list(3.79025e-09 0.73270559 0 1.75216461e-05)
    list(3.79225e-09 0.73270558 0 1.75179334e-05)
    list(3.79425e-09 0.732705571 0 1.75145205e-05)
    list(3.79625e-09 0.732705562 0 1.75113716e-05)
    list(3.79825e-09 0.732705553 0 1.75084571e-05)
    list(3.8e-09 0.732705545 0 1.75051185e-05)
    list(3.80075e-09 0.732694386 0.15 2.72327352e-05)
    list(3.80275e-09 0.732659356 0.55 6.17965593e-05)
    list(3.80475e-09 0.73289477 0.95 9.92442372e-05)
    list(3.80535e-09 0.733006709 1 5.53964973e-05)
    list(3.80725e-09 0.73334012 1 4.70771116e-05)
    list(3.80925e-09 0.733645245 1 4.38308549e-05)
    list(3.81125e-09 0.733931903 1 4.24509278e-05)
    list(3.81325e-09 0.734210629 1 4.17795871e-05)
    list(3.81525e-09 0.734485361 1 4.13999729e-05)
    list(3.81725e-09 0.734757694 1 4.1153226e-05)
    list(3.81925e-09 0.735028353 1 4.09741838e-05)
    list(3.82125e-09 0.735297716 1 4.08335287e-05)
    list(3.82325e-09 0.735566012 1 4.07166505e-05)
    list(3.82525e-09 0.735833394 1 4.06155266e-05)
    list(3.82725e-09 0.736099973 1 4.05253841e-05)
    list(3.82925e-09 0.736365837 1 4.0443205e-05)
    list(3.83015e-09 0.736492775 0.97 3.94932511e-06)
    list(3.83175e-09 0.736733521 0.65 -1.63533019e-05)
    list(3.83375e-09 0.736835622 0.25 -1.50903329e-05)
    list(3.83505e-09 0.736858286 0 2.21913323e-05)
    list(3.83625e-09 0.736858264 0 2.23756464e-05)
    list(3.83825e-09 0.736858239 0 2.03795853e-05)
    list(3.84025e-09 0.736858221 0 1.94734148e-05)
    list(3.84225e-09 0.736858206 0 1.90160549e-05)
    list(3.84425e-09 0.736858192 0 1.87234339e-05)
    list(3.84625e-09 0.736858179 0 1.84968214e-05)
    list(3.84825e-09 0.736858167 0 1.83073362e-05)
    list(3.85025e-09 0.736858155 0 1.81485976e-05)
    list(3.85225e-09 0.736858144 0 1.80186724e-05)
    list(3.85425e-09 0.736858134 0 1.79148447e-05)
    list(3.85625e-09 0.736858123 0 1.78332676e-05)
    list(3.85825e-09 0.736858113 0 1.77697647e-05)
    list(3.86025e-09 0.736858104 0 1.77204668e-05)
    list(3.86225e-09 0.736858094 0 1.76820983e-05)
    list(3.86425e-09 0.736858084 0 1.76520309e-05)
    list(3.86625e-09 0.736858075 0 1.76282263e-05)
    list(3.86825e-09 0.736858066 0 1.76091381e-05)
    list(3.87025e-09 0.736858056 0 1.75936095e-05)
    list(3.87225e-09 0.736858047 0 1.75807827e-05)
    list(3.87425e-09 0.736858037 0 1.75700241e-05)
    list(3.87625e-09 0.736858028 0 1.75608658e-05)
    list(3.87825e-09 0.736858019 0 1.7552962e-05)
    list(3.88025e-09 0.736858009 0 1.75460552e-05)
    list(3.88225e-09 0.736858 0 1.7539953e-05)
    list(3.88425e-09 0.736857991 0 1.75345098e-05)
    list(3.88625e-09 0.736857981 0 1.75296143e-05)
    list(3.88825e-09 0.736857972 0 1.75251808e-05)
    list(3.89025e-09 0.736857963 0 1.75211417e-05)
    list(3.89225e-09 0.736857953 0 1.75174436e-05)
    list(3.89425e-09 0.736857944 0 1.75140434e-05)
    list(3.89625e-09 0.736857935 0 1.75109058e-05)
    list(3.89825e-09 0.736857925 0 1.75080015e-05)
    list(3.9e-09 0.736857917 0 1.75046741e-05)
    list(3.90075e-09 0.736846556 0.15 2.72409811e-05)
    list(3.90275e-09 0.736810709 0.55 6.16740075e-05)
    list(3.90475e-09 0.737041897 0.95 9.82621012e-05)
    list(3.90535e-09 0.737151249 1 5.44960806e-05)
    list(3.90725e-09 0.737478754 1 4.64361755e-05)
    list(3.90925e-09 0.737779491 1 4.33055151e-05)
    list(3.91125e-09 0.738062581 1 4.19742033e-05)
    list(3.91325e-09 0.738338099 1 4.1324325e-05)
    list(3.91525e-09 0.738609791 1 4.09551113e-05)
    list(3.91725e-09 0.738879169 1 4.07141685e-05)
    list(3.91925e-09 0.739146919 1 4.05389111e-05)
    list(3.92125e-09 0.739413404 1 4.04010519e-05)
    list(3.92325e-09 0.739678841 1 4.02864051e-05)
    list(3.92525e-09 0.739943379 1 4.01871371e-05)
    list(3.92725e-09 0.740207127 1 4.00985709e-05)
    list(3.92925e-09 0.740470169 1 4.00177457e-05)
    list(3.93015e-09 0.740595903 0.97 3.57999843e-06)
    list(3.93175e-09 0.740837301 0.65 -1.65184061e-05)
    list(3.93375e-09 0.740940626 0.25 -1.51532887e-05)
    list(3.93505e-09 0.740963681 0 2.21930175e-05)
    list(3.93625e-09 0.740963658 0 2.23713883e-05)
    list(3.93825e-09 0.740963633 0 2.03692183e-05)
    list(3.94025e-09 0.740963615 0 1.94582858e-05)
    list(3.94225e-09 0.7409636 0 1.89969018e-05)
    list(3.94425e-09 0.740963586 0 1.87020001e-05)
    list(3.94625e-09 0.740963573 0 1.84754006e-05)
    list(3.94825e-09 0.740963561 0 1.82878195e-05)
    list(3.95025e-09 0.740963549 0 1.81320239e-05)
    list(3.95225e-09 0.740963538 0 1.80052853e-05)
    list(3.95425e-09 0.740963527 0 1.79043836e-05)
    list(3.95625e-09 0.740963517 0 1.78252555e-05)
    list(3.95825e-09 0.740963507 0 1.77636911e-05)
    list(3.96025e-09 0.740963497 0 1.77158744e-05)
    list(3.96225e-09 0.740963487 0 1.76786113e-05)
    list(3.96425e-09 0.740963477 0 1.76493559e-05)
    list(3.96625e-09 0.740963468 0 1.76261412e-05)
    list(3.96825e-09 0.740963458 0 1.76074783e-05)
    list(3.97025e-09 0.740963449 0 1.75922552e-05)
    list(3.97225e-09 0.740963439 0 1.75796473e-05)
    list(3.97425e-09 0.74096343 0 1.75690455e-05)
    list(3.97625e-09 0.74096342 0 1.75600002e-05)
    list(3.97825e-09 0.740963411 0 1.7552178e-05)
    list(3.98025e-09 0.740963401 0 1.7545331e-05)
    list(3.98225e-09 0.740963392 0 1.75392731e-05)
    list(3.98425e-09 0.740963382 0 1.75338633e-05)
    list(3.98625e-09 0.740963373 0 1.75289937e-05)
    list(3.98825e-09 0.740963363 0 1.75245807e-05)
    list(3.99025e-09 0.740963354 0 1.75205585e-05)
    list(3.99225e-09 0.740963344 0 1.75168748e-05)
    list(3.99425e-09 0.740963335 0 1.75134871e-05)
    list(3.99625e-09 0.740963325 0 1.75103607e-05)
    list(3.99825e-09 0.740963316 0 1.75074669e-05)
    list(4e-09 0.740963307 0 1.75041511e-05)
    list(4.00075e-09 0.740951744 0.15 2.72492049e-05)
    list(4.00275e-09 0.740915098 0.55 6.15505779e-05)
    list(4.00475e-09 0.741141994 0.95 9.72699536e-05)
    list(4.00535e-09 0.741248759 1 5.35982014e-05)
    list(4.00725e-09 0.741570393 1 4.57991334e-05)
    list(4.00925e-09 0.741866777 1 4.27827315e-05)
    list(4.01125e-09 0.742146317 1 4.14987323e-05)
    list(4.01325e-09 0.742418638 1 4.08694756e-05)
    list(4.01525e-09 0.742687294 1 4.05101902e-05)
    list(4.01725e-09 0.742953717 1 4.02747963e-05)
    list(4.01925e-09 0.743218558 1 4.01031818e-05)
    list(4.02125e-09 0.743482162 1 3.99680332e-05)
    list(4.02325e-09 0.743744737 1 3.98555614e-05)
    list(4.02525e-09 0.744006428 1 3.97581086e-05)
    list(4.02725e-09 0.74426734 1 3.96710871e-05)
    list(4.02925e-09 0.744527556 1 3.95915907e-05)
    list(4.03015e-09 0.744652084 0.97 3.20974434e-06)
    list(4.03175e-09 0.744894096 0.65 -1.66757006e-05)
    list(4.03375e-09 0.744998647 0.25 -1.52017845e-05)
    list(4.03505e-09 0.745022091 0 2.21946379e-05)
    list(4.03625e-09 0.745022068 0 2.23670013e-05)
    list(4.03825e-09 0.745022042 0 2.0358579e-05)
    list(4.04025e-09 0.745022024 0 1.94427493e-05)
    list(4.04225e-09 0.745022009 0 1.89773951e-05)
    list(4.04425e-09 0.745021995 0 1.86804387e-05)
    list(4.04625e-09 0.745021982 0 1.84541001e-05)
    list(4.04825e-09 0.745021969 0 1.82685891e-05)
    list(4.05025e-09 0.745021958 0 1.81157974e-05)
    list(4.05225e-09 0.745021947 0 1.79922275e-05)
    list(4.05425e-09 0.745021936 0 1.78941939e-05)
    list(4.05625e-09 0.745021925 0 1.78174456e-05)
    list(4.05825e-09 0.745021915 0 1.77577545e-05)
    list(4.06025e-09 0.745021905 0 1.77113638e-05)
    list(4.06225e-09 0.745021895 0 1.76751623e-05)
    list(4.06425e-09 0.745021886 0 1.7646685e-05)
    list(4.06625e-09 0.745021876 0 1.76240347e-05)
    list(4.06825e-09 0.745021866 0 1.76057786e-05)
    list(4.07025e-09 0.745021856 0 1.75908472e-05)
    list(4.07225e-09 0.745021847 0 1.75784483e-05)
    list(4.07425e-09 0.745021837 0 1.75679966e-05)
    list(4.07625e-09 0.745021828 0 1.75590593e-05)
    list(4.07825e-09 0.745021818 0 1.75513155e-05)
    list(4.08025e-09 0.745021808 0 1.7544526e-05)
    list(4.08225e-09 0.745021799 0 1.75385109e-05)
    list(4.08425e-09 0.745021789 0 1.75331338e-05)
    list(4.08625e-09 0.745021779 0 1.75282897e-05)
    list(4.08825e-09 0.74502177 0 1.75238973e-05)
    list(4.09025e-09 0.74502176 0 1.75198922e-05)
    list(4.09225e-09 0.745021751 0 1.75162232e-05)
    list(4.09425e-09 0.745021741 0 1.75128486e-05)
    list(4.09625e-09 0.745021731 0 1.75097342e-05)
    list(4.09825e-09 0.745021722 0 1.75068515e-05)
    list(4.1e-09 0.745021713 0 1.75035484e-05)
    list(4.10075e-09 0.745009948 0.15 2.72574027e-05)
    list(4.10275e-09 0.74497252 0.55 6.14262066e-05)
    list(4.10475e-09 0.745195058 0.95 9.62686713e-05)
    list(4.10535e-09 0.745299238 1 5.27033072e-05)
    list(4.10725e-09 0.745615039 1 4.5166078e-05)
    list(4.10925e-09 0.745907103 1 4.22625167e-05)
    list(4.11125e-09 0.746183115 1 4.10245356e-05)
    list(4.11325e-09 0.746452249 1 4.04150911e-05)
    list(4.11525e-09 0.746717874 1 4.00652905e-05)
    list(4.11725e-09 0.746981344 1 3.98352109e-05)
    list(4.11925e-09 0.747243275 1 3.96671112e-05)
    list(4.12125e-09 0.747503995 1 3.95345974e-05)
    list(4.12325e-09 0.747763706 1 3.9424251e-05)
    list(4.12525e-09 0.748022548 1 3.93285777e-05)
    list(4.12725e-09 0.748280621 1 3.92430738e-05)
    list(4.12925e-09 0.748538008 1 3.91648847e-05)
    list(4.13015e-09 0.748661327 0.97 2.83879271e-06)
    list(4.13175e-09 0.748903916 0.65 -1.6824929e-05)
    list(4.13375e-09 0.749009695 0.25 -1.52361716e-05)
    list(4.13505e-09 0.749033525 0 2.2196181e-05)
    list(4.13625e-09 0.749033501 0 2.23624693e-05)
    list(4.13825e-09 0.749033475 0 2.03476453e-05)
    list(4.14025e-09 0.749033457 0 1.94267994e-05)
    list(4.14225e-09 0.749033442 0 1.89575571e-05)
    list(4.14425e-09 0.749033428 0 1.86587848e-05)
    list(4.14625e-09 0.749033415 0 1.84329493e-05)
    list(4.14825e-09 0.749033402 0 1.82496613e-05)
    list(4.15025e-09 0.749033391 0 1.80999226e-05)
    list(4.15225e-09 0.749033379 0 1.79794964e-05)
    list(4.15425e-09 0.749033368 0 1.78842702e-05)
    list(4.15625e-09 0.749033358 0 1.78098322e-05)
    list(4.15825e-09 0.749033348 0 1.77519504e-05)
    list(4.16025e-09 0.749033338 0 1.77069319e-05)
    list(4.16225e-09 0.749033328 0 1.76717493e-05)
    list(4.16425e-09 0.749033318 0 1.76440176e-05)
    list(4.16625e-09 0.749033308 0 1.76219074e-05)
    list(4.16825e-09 0.749033298 0 1.76040399e-05)
    list(4.17025e-09 0.749033288 0 1.75893873e-05)
    list(4.17225e-09 0.749033278 0 1.75771882e-05)
    list(4.17425e-09 0.749033269 0 1.75668798e-05)
    list(4.17625e-09 0.749033259 0 1.75580459e-05)
    list(4.17825e-09 0.749033249 0 1.75503774e-05)
    list(4.18025e-09 0.749033239 0 1.75436433e-05)
    list(4.18225e-09 0.74903323 0 1.75376699e-05)
    list(4.18425e-09 0.74903322 0 1.75323246e-05)
    list(4.18625e-09 0.74903321 0 1.75275058e-05)
    list(4.18825e-09 0.7490332 0 1.75231339e-05)
    list(4.19025e-09 0.749033191 0 1.75191463e-05)
    list(4.19225e-09 0.749033181 0 1.75154924e-05)
    list(4.19425e-09 0.749033171 0 1.75121315e-05)
    list(4.19625e-09 0.749033161 0 1.75090297e-05)
    list(4.19825e-09 0.749033152 0 1.75061589e-05)
    list(4.2e-09 0.749033143 0 1.75028694e-05)
    list(4.20075e-09 0.749021175 0.15 2.72655707e-05)
    list(4.20275e-09 0.748982984 0.55 6.13008276e-05)
    list(4.20475e-09 0.749201098 0.95 9.52592409e-05)
    list(4.20535e-09 0.749302698 1 5.18120547e-05)
    list(4.20725e-09 0.749612708 1 4.45372578e-05)
    list(4.20925e-09 0.749900486 1 4.17450112e-05)
    list(4.21125e-09 0.750172991 1 4.05517441e-05)
    list(4.21325e-09 0.750438948 1 3.99613188e-05)
    list(4.21525e-09 0.750701547 1 3.96205747e-05)
    list(4.21725e-09 0.750962066 1 3.93955833e-05)
    list(4.21925e-09 0.751221087 1 3.92308738e-05)
    list(4.22125e-09 0.751478924 1 3.91009197e-05)
    list(4.22325e-09 0.75173577 1 3.89926483e-05)
    list(4.22525e-09 0.75199176 1 3.88987177e-05)
    list(4.22725e-09 0.752246993 1 3.88147028e-05)
    list(4.22925e-09 0.752501548 1 3.87377979e-05)
    list(4.23015e-09 0.752623658 0.97 2.46736524e-06)
    list(4.23175e-09 0.752866784 0.65 -1.69660402e-05)
    list(4.23375e-09 0.752973793 0.25 -1.52571622e-05)
    list(4.23505e-09 0.752998006 0 2.21976287e-05)
    list(4.23625e-09 0.752997983 0 2.23577726e-05)
    list(4.23825e-09 0.752997957 0 2.03363934e-05)
    list(4.24025e-09 0.752997938 0 1.9410432e-05)
    list(4.24225e-09 0.752997923 0 1.89374121e-05)
    list(4.24425e-09 0.752997909 0 1.86370722e-05)
    list(4.24625e-09 0.752997896 0 1.84119752e-05)
    list(4.24825e-09 0.752997883 0 1.82310504e-05)
    list(4.25025e-09 0.752997871 0 1.80844028e-05)
    list(4.25225e-09 0.75299786 0 1.79670892e-05)
    list(4.25425e-09 0.752997849 0 1.78746075e-05)
    list(4.25625e-09 0.752997838 0 1.78024109e-05)
    list(4.25825e-09 0.752997828 0 1.77462755e-05)
    list(4.26025e-09 0.752997818 0 1.77025772e-05)
    list(4.26225e-09 0.752997808 0 1.76683725e-05)
    list(4.26425e-09 0.752997798 0 1.7641355e-05)
    list(4.26625e-09 0.752997788 0 1.76197616e-05)
    list(4.26825e-09 0.752997778 0 1.76022657e-05)
    list(4.27025e-09 0.752997768 0 1.75878795e-05)
    list(4.27225e-09 0.752997758 0 1.75758712e-05)
    list(4.27425e-09 0.752997748 0 1.75657e-05)
    list(4.27625e-09 0.752997738 0 1.75569652e-05)
    list(4.27825e-09 0.752997728 0 1.75493689e-05)
    list(4.28025e-09 0.752997718 0 1.75426884e-05)
    list(4.28225e-09 0.752997708 0 1.75367553e-05)
    list(4.28425e-09 0.752997699 0 1.75314414e-05)
    list(4.28625e-09 0.752997689 0 1.75266475e-05)
    list(4.28825e-09 0.752997679 0 1.75222963e-05)
    list(4.29025e-09 0.752997669 0 1.75183262e-05)
    list(4.29225e-09 0.752997659 0 1.7514688e-05)
    list(4.29425e-09 0.752997649 0 1.75113412e-05)
    list(4.29625e-09 0.752997639 0 1.75082526e-05)
    list(4.29825e-09 0.752997629 0 1.75053944e-05)
    list(4.3e-09 0.752997621 0 1.75021196e-05)
    list(4.30075e-09 0.752985451 0.15 2.72737051e-05)
    list(4.30275e-09 0.752946513 0.55 6.11743721e-05)
    list(4.30475e-09 0.753160139 0.95 9.42427582e-05)
    list(4.30535e-09 0.753259165 1 5.09249897e-05)
    list(4.30725e-09 0.753563429 1 4.39142311e-05)
    list(4.30925e-09 0.753846961 1 4.12303892e-05)
    list(4.31125e-09 0.75411598 1 4.00804706e-05)
    list(4.31325e-09 0.754378773 1 3.95082747e-05)
    list(4.31525e-09 0.754638352 1 3.91761725e-05)
    list(4.31725e-09 0.754895922 1 3.89560543e-05)
    list(4.31925e-09 0.755152034 1 3.87946172e-05)
    list(4.32125e-09 0.755406988 1 3.86671517e-05)
    list(4.32325e-09 0.755660969 1 3.85609075e-05)
    list(4.32525e-09 0.755914106 1 3.84686842e-05)
    list(4.32725e-09 0.756166498 1 3.83861308e-05)
    list(4.32925e-09 0.75641822 1 3.83104882e-05)
    list(4.33015e-09 0.75653912 0.97 2.09567753e-06)
    list(4.33175e-09 0.756782747 0.65 -1.70991453e-05)
    list(4.33375e-09 0.756890987 0.25 -1.52657687e-05)
    list(4.33505e-09 0.756915581 0 2.21989553e-05)
    list(4.33625e-09 0.756915557 0 2.23528858e-05)
    list(4.33825e-09 0.756915531 0 2.03247976e-05)
    list(4.34025e-09 0.756915512 0 1.93936445e-05)
    list(4.34225e-09 0.756915497 0 1.89169842e-05)
    list(4.34425e-09 0.756915483 0 1.86153327e-05)
    list(4.34625e-09 0.756915469 0 1.8391202e-05)
    list(4.34825e-09 0.756915457 0 1.82127682e-05)
    list(4.35025e-09 0.756915445 0 1.80692398e-05)
    list(4.35225e-09 0.756915434 0 1.79550025e-05)
    list(4.35425e-09 0.756915423 0 1.78652014e-05)
    list(4.35625e-09 0.756915412 0 1.77951781e-05)
    list(4.35825e-09 0.756915401 0 1.7740728e-05)
    list(4.36025e-09 0.756915391 0 1.76982997e-05)
    list(4.36225e-09 0.756915381 0 1.76650334e-05)
    list(4.36425e-09 0.756915371 0 1.76387003e-05)
    list(4.36625e-09 0.75691536 0 1.76176014e-05)
    list(4.36825e-09 0.75691535 0 1.76004608e-05)
    list(4.37025e-09 0.75691534 0 1.75863293e-05)
    list(4.37225e-09 0.75691533 0 1.75745036e-05)
    list(4.37425e-09 0.75691532 0 1.75644636e-05)
    list(4.37625e-09 0.75691531 0 1.75558237e-05)
    list(4.37825e-09 0.7569153 0 1.75482971e-05)
    list(4.38025e-09 0.75691529 0 1.75416683e-05)
    list(4.38225e-09 0.75691528 0 1.75357745e-05)
    list(4.38425e-09 0.75691527 0 1.75304913e-05)
    list(4.38625e-09 0.75691526 0 1.75257222e-05)
    list(4.38825e-09 0.75691525 0 1.75213916e-05)
    list(4.39025e-09 0.75691524 0 1.75174394e-05)
    list(4.39225e-09 0.75691523 0 1.75138171e-05)
    list(4.39425e-09 0.75691522 0 1.7510485e-05)
    list(4.39625e-09 0.75691521 0 1.75074102e-05)
    list(4.39825e-09 0.7569152 0 1.75045652e-05)
    list(4.4e-09 0.756915191 0 1.75013058e-05)
    list(4.40075e-09 0.756902819 0.15 2.72818022e-05)
    list(4.40275e-09 0.756863151 0.55 6.10467684e-05)
    list(4.40475e-09 0.757072229 0.95 9.32204224e-05)
    list(4.40535e-09 0.75716869 1 5.0042613e-05)
    list(4.40725e-09 0.757467251 1 4.32943064e-05)
    list(4.40925e-09 0.757746569 1 4.0718591e-05)
    list(4.41125e-09 0.758012123 1 3.96107932e-05)
    list(4.41325e-09 0.758271763 1 3.9056099e-05)
    list(4.41525e-09 0.758528329 1 3.87322521e-05)
    list(4.41725e-09 0.758782954 1 3.85168032e-05)
    list(4.41925e-09 0.75903616 1 3.83585243e-05)
    list(4.42125e-09 0.759288231 1 3.82334763e-05)
    list(4.42325e-09 0.759539347 1 3.812921e-05)
    list(4.42525e-09 0.759789633 1 3.80386568e-05)
    list(4.42725e-09 0.760039183 1 3.79575356e-05)
    list(4.42925e-09 0.760288072 1 3.78831314e-05)
    list(4.43015e-09 0.760407762 0.97 1.72393555e-06)
    list(4.43175e-09 0.760651851 0.65 -1.72245186e-05)
    list(4.43375e-09 0.760761322 0.25 -1.52632451e-05)
    list(4.43505e-09 0.760786295 0 2.22001564e-05)
    list(4.43625e-09 0.760786271 0 2.23477995e-05)
    list(4.43825e-09 0.760786244 0 2.03128454e-05)
    list(4.44025e-09 0.760786225 0 1.93764485e-05)
    list(4.44225e-09 0.76078621 0 1.88963092e-05)
    list(4.44425e-09 0.760786195 0 1.85936067e-05)
    list(4.44625e-09 0.760786182 0 1.83706604e-05)
    list(4.44825e-09 0.76078617 0 1.81948318e-05)
    list(4.45025e-09 0.760786158 0 1.80544405e-05)
    list(4.45225e-09 0.760786146 0 1.79432379e-05)
    list(4.45425e-09 0.760786135 0 1.78560517e-05)
    list(4.45625e-09 0.760786124 0 1.7788134e-05)
    list(4.45825e-09 0.760786114 0 1.77353095e-05)
    list(4.46025e-09 0.760786103 0 1.76941024e-05)
    list(4.46225e-09 0.760786093 0 1.76617366e-05)
    list(4.46425e-09 0.760786082 0 1.76360589e-05)
    list(4.46625e-09 0.760786072 0 1.76154332e-05)
    list(4.46825e-09 0.760786062 0 1.75986324e-05)
    list(4.47025e-09 0.760786052 0 1.75847443e-05)
    list(4.47225e-09 0.760786042 0 1.75730932e-05)
    list(4.47425e-09 0.760786031 0 1.75631788e-05)
    list(4.47625e-09 0.760786021 0 1.75546302e-05)
    list(4.47825e-09 0.760786011 0 1.75471704e-05)
    list(4.48025e-09 0.760786001 0 1.75405916e-05)
    list(4.48225e-09 0.760785991 0 1.75347361e-05)
    list(4.48425e-09 0.760785981 0 1.7529483e-05)
    list(4.48625e-09 0.76078597 0 1.75247384e-05)
    list(4.48825e-09 0.76078596 0 1.75204285e-05)
    list(4.49025e-09 0.76078595 0 1.75164944e-05)
    list(4.49225e-09 0.76078594 0 1.75128884e-05)
    list(4.49425e-09 0.76078593 0 1.75095714e-05)
    list(4.49625e-09 0.76078592 0 1.75065109e-05)
    list(4.49825e-09 0.760785909 0 1.75036796e-05)
    list(4.5e-09 0.760785901 1.65436123e-13 1.75004365e-05)
    list(4.50075e-09 0.760773328 0.15 2.72898583e-05)
    list(4.50275e-09 0.760732945 0.55 6.09179422e-05)
    list(4.50475e-09 0.760937413 0.95 9.21935338e-05)
    list(4.50535e-09 0.761031321 1 4.91653849e-05)
    list(4.50725e-09 0.761324226 1 4.26791344e-05)
    list(4.50925e-09 0.761599367 1 4.02097881e-05)
    list(4.51125e-09 0.761861479 1 3.91428243e-05)
    list(4.51325e-09 0.762117978 1 3.86049072e-05)
    list(4.51525e-09 0.762371537 1 3.82889413e-05)
    list(4.51725e-09 0.762623222 1 3.80779678e-05)
    list(4.51925e-09 0.762873525 1 3.79227393e-05)
    list(4.52125e-09 0.763122716 1 3.78000417e-05)
    list(4.52325e-09 0.763370969 1 3.76977065e-05)
    list(4.52525e-09 0.763618404 1 3.76087882e-05)
    list(4.52725e-09 0.763865114 1 3.75290711e-05)
    list(4.52925e-09 0.764111171 1 3.74558827e-05)
    list(4.53015e-09 0.764229651 0.97 1.35233942e-06)
    list(4.53175e-09 0.764474165 0.65 -1.73425207e-05)
    list(4.53375e-09 0.764584867 0.25 -1.52510351e-05)
    list(4.53505e-09 0.764610215 0 2.22012054e-05)
    list(4.53625e-09 0.764610191 0 2.2342488e-05)
    list(4.53825e-09 0.764610164 0 2.03005157e-05)
    list(4.54025e-09 0.764610145 0 1.93588502e-05)
    list(4.54225e-09 0.764610129 0 1.88754168e-05)
    list(4.54425e-09 0.764610115 0 1.85719266e-05)
    list(4.54625e-09 0.764610101 0 1.83503729e-05)
    list(4.54825e-09 0.764610089 0 1.81772516e-05)
    list(4.55025e-09 0.764610077 0 1.80400066e-05)
    list(4.55225e-09 0.764610065 0 1.79317933e-05)
    list(4.55425e-09 0.764610054 0 1.78471561e-05)
    list(4.55625e-09 0.764610043 0 1.77812776e-05)
    list(4.55825e-09 0.764610032 0 1.7730021e-05)
    list(4.56025e-09 0.764610022 0 1.76899881e-05)
    list(4.56225e-09 0.764610011 0 1.76584863e-05)
    list(4.56425e-09 0.764610001 0 1.76334368e-05)
    list(4.56625e-09 0.764609991 0 1.7613264e-05)
    list(4.56825e-09 0.76460998 0 1.75967883e-05)
    list(4.57025e-09 0.76460997 0 1.75831331e-05)
    list(4.57225e-09 0.76460996 0 1.75716489e-05)
    list(4.57425e-09 0.764609949 0 1.7561855e-05)
    list(4.57625e-09 0.764609939 0 1.75533938e-05)
    list(4.57825e-09 0.764609929 0 1.75459985e-05)
    list(4.58025e-09 0.764609918 0 1.75394682e-05)
    list(4.58225e-09 0.764609908 0 1.75336499e-05)
    list(4.58425e-09 0.764609898 0 1.75284263e-05)
    list(4.58625e-09 0.764609887 0 1.7523706e-05)
    list(4.58825e-09 0.764609877 0 1.75194168e-05)
    list(4.59025e-09 0.764609867 0 1.75155009e-05)
    list(4.59225e-09 0.764609857 0 1.75119114e-05)
    list(4.59425e-09 0.764609846 0 1.75086099e-05)
    list(4.59625e-09 0.764609836 0 1.75055642e-05)
    list(4.59825e-09 0.764609826 0 1.75027471e-05)
    list(4.6e-09 0.764609817 0 1.74995209e-05)
    list(4.60075e-09 0.764597043 0.15 2.72978699e-05)
    list(4.60275e-09 0.764555961 0.55 6.07878161e-05)
    list(4.60475e-09 0.764755763 0.95 9.11634772e-05)
    list(4.60535e-09 0.76484713 1 4.82937221e-05)
    list(4.60725e-09 0.765134428 1 4.2068854e-05)
    list(4.60925e-09 0.765405429 1 3.97040626e-05)
    list(4.61125e-09 0.76566412 1 3.867666e-05)
    list(4.61325e-09 0.765917492 1 3.81548195e-05)
    list(4.61525e-09 0.766168053 1 3.78463782e-05)
    list(4.61725e-09 0.766416802 1 3.76396964e-05)
    list(4.61925e-09 0.766664205 1 3.74874156e-05)
    list(4.62125e-09 0.76691052 1 3.73670039e-05)
    list(4.62325e-09 0.767155912 1 3.72665544e-05)
    list(4.62525e-09 0.767400499 1 3.71792365e-05)
    list(4.62725e-09 0.767644371 1 3.7100896e-05)
    list(4.62925e-09 0.767887598 1 3.7028901e-05)
    list(4.63015e-09 0.768004868 0.97 9.81079085e-07)
    list(4.63175e-09 0.768249771 0.65 -1.74535994e-05)
    list(4.63375e-09 0.768361703 0.25 -1.52307093e-05)
    list(4.63505e-09 0.768387424 0 2.22020833e-05)
    list(4.63625e-09 0.768387399 0 2.23369314e-05)
    list(4.63825e-09 0.768387372 0 2.02877941e-05)
    list(4.64025e-09 0.768387353 0 1.93408634e-05)
    list(4.64225e-09 0.768387337 0 1.8854341e-05)
    list(4.64425e-09 0.768387323 0 1.8550327e-05)
    list(4.64625e-09 0.768387309 0 1.83303632e-05)
    list(4.64825e-09 0.768387297 0 1.81600392e-05)
    list(4.65025e-09 0.768387285 0 1.80259414e-05)
    list(4.65225e-09 0.768387273 0 1.79206686e-05)
    list(4.65425e-09 0.768387262 0 1.78385142e-05)
    list(4.65625e-09 0.768387251 0 1.77746099e-05)
    list(4.65825e-09 0.76838724 0 1.77248648e-05)
    list(4.66025e-09 0.768387229 0 1.7685961e-05)
    list(4.66225e-09 0.768387218 0 1.76552884e-05)
    list(4.66425e-09 0.768387208 0 1.76308408e-05)
    list(4.66625e-09 0.768387197 0 1.76111017e-05)
    list(4.66825e-09 0.768387187 0 1.75949371e-05)
    list(4.67025e-09 0.768387176 0 1.75815047e-05)
    list(4.67225e-09 0.768387166 0 1.75701806e-05)
    list(4.67425e-09 0.768387156 0 1.7560502e-05)
    list(4.67625e-09 0.768387145 0 1.75521249e-05)
    list(4.67825e-09 0.768387135 0 1.75447918e-05)
    list(4.68025e-09 0.768387124 0 1.75383082e-05)
    list(4.68225e-09 0.768387114 0 1.75325263e-05)
    list(4.68425e-09 0.768387103 0 1.75273317e-05)
    list(4.68625e-09 0.768387093 0 1.75226354e-05)
    list(4.68825e-09 0.768387082 0 1.75183668e-05)
    list(4.69025e-09 0.768387072 0 1.75144692e-05)
    list(4.69225e-09 0.768387062 0 1.75108966e-05)
    list(4.69425e-09 0.768387051 0 1.75076108e-05)
    list(4.69625e-09 0.768387041 0 1.75045801e-05)
    list(4.69825e-09 0.76838703 0 1.75017776e-05)
    list(4.7e-09 0.768387021 0 1.74985688e-05)
    list(4.70075e-09 0.768374047 0.15 2.73058337e-05)
    list(4.70275e-09 0.768332282 0.55 6.06563097e-05)
    list(4.70475e-09 0.76852736 0.95 9.01317071e-05)
    list(4.70535e-09 0.768616202 1 4.74280005e-05)
    list(4.70725e-09 0.768897944 1 4.1463588e-05)
    list(4.70925e-09 0.769164843 1 3.92014894e-05)
    list(4.71125e-09 0.769420136 1 3.82123923e-05)
    list(4.71325e-09 0.769670394 1 3.77059531e-05)
    list(4.71525e-09 0.769917964 1 3.74046974e-05)
    list(4.71725e-09 0.770163784 1 3.72021333e-05)
    list(4.71925e-09 0.770408293 1 3.70527028e-05)
    list(4.72125e-09 0.770651735 1 3.69345152e-05)
    list(4.72325e-09 0.77089427 1 3.68359076e-05)
    list(4.72525e-09 0.771136012 1 3.67501563e-05)
    list(4.72725e-09 0.771377048 1 3.66731655e-05)
    list(4.72925e-09 0.771617448 1 3.66023422e-05)
    list(4.73015e-09 0.77173351 0.97 6.10334999e-07)
    list(4.73175e-09 0.771978766 0.65 -1.75582574e-05)
    list(4.73375e-09 0.772091927 0.25 -1.52039139e-05)
    list(4.73505e-09 0.772118017 0 2.22027712e-05)
    list(4.73625e-09 0.772117992 0 2.23311101e-05)
    list(4.73825e-09 0.772117965 0 2.02746693e-05)
    list(4.74025e-09 0.772117946 0 1.93225712e-05)
    list(4.74225e-09 0.77211793 0 1.88331273e-05)
    list(4.74425e-09 0.772117915 0 1.85288443e-05)
    list(4.74625e-09 0.772117902 0 1.83106556e-05)
    list(4.74825e-09 0.772117889 0 1.81432061e-05)
    list(4.75025e-09 0.772117877 0 1.80122486e-05)
    list(4.75225e-09 0.772117865 0 1.79098642e-05)
    list(4.75425e-09 0.772117854 0 1.78301262e-05)
    list(4.75625e-09 0.772117842 0 1.77681321e-05)
    list(4.75825e-09 0.772117832 0 1.77198443e-05)
    list(4.76025e-09 0.772117821 0 1.7682026e-05)
    list(4.76225e-09 0.77211781 0 1.76521492e-05)
    list(4.76425e-09 0.772117799 0 1.76282785e-05)
    list(4.76625e-09 0.772117789 0 1.76089547e-05)
    list(4.76825e-09 0.772117778 0 1.75930879e-05)
    list(4.77025e-09 0.772117767 0 1.75798689e-05)
    list(4.77225e-09 0.772117757 0 1.75686979e-05)
    list(4.77425e-09 0.772117746 0 1.75591301e-05)
    list(4.77625e-09 0.772117736 0 1.75508338e-05)
    list(4.77825e-09 0.772117725 0 1.75435606e-05)
    list(4.78025e-09 0.772117715 0 1.75371225e-05)
    list(4.78225e-09 0.772117704 0 1.75313759e-05)
    list(4.78425e-09 0.772117693 0 1.75262098e-05)
    list(4.78625e-09 0.772117683 0 1.75215372e-05)
    list(4.78825e-09 0.772117672 0 1.75172891e-05)
    list(4.79025e-09 0.772117662 0 1.75134099e-05)
    list(4.79225e-09 0.772117651 0 1.75098541e-05)
    list(4.79425e-09 0.772117641 0 1.75065843e-05)
    list(4.79625e-09 0.77211763 0 1.75035689e-05)
    list(4.79825e-09 0.772117619 0 1.75007813e-05)
    list(4.8e-09 0.77211761 0 1.74975903e-05)
    list(4.80075e-09 0.772104436 0.15 2.73137465e-05)
    list(4.80275e-09 0.772062002 0.55 6.05233392e-05)
    list(4.80475e-09 0.772252305 0.95 8.91005449e-05)
    list(4.80535e-09 0.772338638 1 4.65686068e-05)
    list(4.80725e-09 0.772614877 1 4.08634614e-05)
    list(4.80925e-09 0.772877711 1 3.87021427e-05)
    list(4.81125e-09 0.773129629 1 3.77501123e-05)
    list(4.81325e-09 0.773376787 1 3.72584232e-05)
    list(4.81525e-09 0.773621376 1 3.69640303e-05)
    list(4.81725e-09 0.773864274 1 3.67654196e-05)
    list(4.81925e-09 0.774105893 1 3.66187469e-05)
    list(4.82125e-09 0.774346468 1 3.65027244e-05)
    list(4.82325e-09 0.77458615 1 3.64059163e-05)
    list(4.82525e-09 0.774825051 1 3.63216991e-05)
    list(4.82725e-09 0.775063256 1 3.62460318e-05)
    list(4.82925e-09 0.775300833 1 3.61763587e-05)
    list(4.83015e-09 0.775415688 0.97 2.39957057e-07)
    list(4.83175e-09 0.775661263 0.65 -1.76570038e-05)
    list(4.83375e-09 0.77577565 0.25 -1.51722978e-05)
    list(4.83505e-09 0.775802107 0 2.22032488e-05)
    list(4.83625e-09 0.775802081 0 2.23250037e-05)
    list(4.83825e-09 0.775802053 0 2.02612678e-05)
    list(4.84025e-09 0.775802034 0 1.93039149e-05)
    list(4.84225e-09 0.775802018 0 1.88118066e-05)
    list(4.84425e-09 0.775802004 0 1.85075138e-05)
    list(4.84625e-09 0.77580199 0 1.82912681e-05)
    list(4.84825e-09 0.775801977 0 1.81267567e-05)
    list(4.85025e-09 0.775801965 0 1.79989245e-05)
    list(4.85225e-09 0.775801953 0 1.78993737e-05)
    list(4.85425e-09 0.775801942 0 1.78219863e-05)
    list(4.85625e-09 0.77580193 0 1.77618406e-05)
    list(4.85825e-09 0.775801919 0 1.7714958e-05)
    list(4.86025e-09 0.775801908 0 1.76781843e-05)
    list(4.86225e-09 0.775801898 0 1.76490719e-05)
    list(4.86425e-09 0.775801887 0 1.7625755e-05)
    list(4.86625e-09 0.775801876 0 1.76068296e-05)
    list(4.86825e-09 0.775801865 0 1.75912486e-05)
    list(4.87025e-09 0.775801854 0 1.75782345e-05)
    list(4.87225e-09 0.775801844 0 1.75672109e-05)
    list(4.87425e-09 0.775801833 0 1.75577497e-05)
    list(4.87625e-09 0.775801822 0 1.75495315e-05)
    list(4.87825e-09 0.775801812 0 1.75423165e-05)
    list(4.88025e-09 0.775801801 0 1.75359226e-05)
    list(4.88225e-09 0.77580179 0 1.75302107e-05)
    list(4.88425e-09 0.775801779 0 1.75250727e-05)
    list(4.88625e-09 0.775801769 0 1.75204238e-05)
    list(4.88825e-09 0.775801758 0 1.75161962e-05)
    list(4.89025e-09 0.775801747 0 1.75123354e-05)
    list(4.89225e-09 0.775801737 0 1.75087968e-05)
    list(4.89425e-09 0.775801726 0 1.75055431e-05)
    list(4.89625e-09 0.775801715 0 1.75025433e-05)
    list(4.89825e-09 0.775801704 0 1.74997708e-05)
    list(4.9e-09 0.775801695 0 1.74965979e-05)
    list(4.90075e-09 0.775788322 0.15 2.73216052e-05)
    list(4.90275e-09 0.775745234 0.55 6.03888174e-05)
    list(4.90475e-09 0.775930709 0.95 8.80700155e-05)
    list(4.90535e-09 0.776014551 1 4.57157548e-05)
    list(4.90725e-09 0.776285339 1 4.02685347e-05)
    list(4.90925e-09 0.776544148 1 3.82060714e-05)
    list(4.91125e-09 0.776792713 1 3.72898982e-05)
    list(4.91325e-09 0.777036785 1 3.68123357e-05)
    list(4.91525e-09 0.777278404 1 3.65245011e-05)
    list(4.91725e-09 0.777518387 1 3.63296891e-05)
    list(4.91925e-09 0.777757124 1 3.61856874e-05)
    list(4.92125e-09 0.777994836 1 3.6071774e-05)
    list(4.92325e-09 0.778231671 1 3.59767251e-05)
    list(4.92525e-09 0.778467737 1 3.58940106e-05)
    list(4.92725e-09 0.778703116 1 3.58196418e-05)
    list(4.92925e-09 0.778937873 1 3.57510986e-05)
    list(4.93015e-09 0.779051524 0.97 -1.29266367e-07)
    list(4.93175e-09 0.779297384 0.65 -1.77504441e-05)
    list(4.93375e-09 0.779412995 0.25 -1.51375629e-05)
    list(4.93505e-09 0.779439814 0 2.22035013e-05)
    list(4.93625e-09 0.779439788 0 2.23185963e-05)
    list(4.93825e-09 0.77943976 0 2.02473169e-05)
    list(4.94025e-09 0.779439741 0 1.9284882e-05)
    list(4.94225e-09 0.779439725 0 1.87903965e-05)
    list(4.94425e-09 0.77943971 0 1.84863545e-05)
    list(4.94625e-09 0.779439696 0 1.82722201e-05)
    list(4.94825e-09 0.779439684 0 1.81107058e-05)
    list(4.95025e-09 0.779439671 0 1.79859808e-05)
    list(4.95225e-09 0.779439659 0 1.78892082e-05)
    list(4.95425e-09 0.779439648 0 1.7814106e-05)
    list(4.95625e-09 0.779439636 0 1.7755748e-05)
    list(4.95825e-09 0.779439625 0 1.77102195e-05)
    list(4.96025e-09 0.779439614 0 1.76744497e-05)
    list(4.96225e-09 0.779439603 0 1.76460707e-05)
    list(4.96425e-09 0.779439592 0 1.76232843e-05)
    list(4.96625e-09 0.779439581 0 1.76047404e-05)
    list(4.96825e-09 0.77943957 0 1.75894326e-05)
    list(4.97025e-09 0.77943956 0 1.75766144e-05)
    list(4.97225e-09 0.779439549 0 1.75657316e-05)
    list(4.97425e-09 0.779439538 0 1.75563724e-05)
    list(4.97625e-09 0.779439527 0 1.75482291e-05)
    list(4.97825e-09 0.779439516 0 1.75410698e-05)
    list(4.98025e-09 0.779439505 0 1.75347186e-05)
    list(4.98225e-09 0.779439494 0 1.75290402e-05)
    list(4.98425e-09 0.779439484 0 1.75239294e-05)
    list(4.98625e-09 0.779439473 0 1.75193035e-05)
    list(4.98825e-09 0.779439462 0 1.7515096e-05)
    list(4.99025e-09 0.779439451 0 1.75112535e-05)
    list(4.99225e-09 0.77943944 0 1.75077317e-05)
    list(4.99425e-09 0.779439429 0 1.75044941e-05)
    list(4.99625e-09 0.779439418 0 1.75015098e-05)
    list(4.99825e-09 0.779439408 0 1.74987524e-05)
    list(5e-09 0.779439398 0 1.74955977e-05)
    list(5.00075e-09 0.779425827 0.15 2.73294067e-05)
    list(5.00275e-09 0.779382098 0.55 6.0252654e-05)
    list(5.00475e-09 0.779562697 0.95 8.70423626e-05)
    list(5.00535e-09 0.779644067 1 4.48697559e-05)
    list(5.00725e-09 0.779909464 1 3.967893e-05)
    list(5.00925e-09 0.780164286 1 3.77133191e-05)
    list(5.01125e-09 0.780409523 1 3.68317941e-05)
    list(5.01325e-09 0.780650524 1 3.63677592e-05)
    list(5.01525e-09 0.780889183 1 3.60861984e-05)
    list(5.01725e-09 0.78112626 1 3.58950445e-05)
    list(5.01925e-09 0.781362122 1 3.57536357e-05)
    list(5.02125e-09 0.781596979 1 3.56417818e-05)
    list(5.02325e-09 0.781830973 1 3.55484564e-05)
    list(5.02525e-09 0.782064209 1 3.54672171e-05)
    list(5.02725e-09 0.782296767 1 3.53941246e-05)
    list(5.02925e-09 0.782528712 1 3.53266932e-05)
    list(5.03015e-09 0.78264116 0.97 -4.9714424e-07)
    list(5.03175e-09 0.782887269 0.65 -1.78391518e-05)
    list(5.03375e-09 0.783004101 0.25 -1.51013208e-05)
    list(5.03505e-09 0.783031279 0 2.2203506e-05)
    list(5.03625e-09 0.783031253 0 2.23118677e-05)
    list(5.03825e-09 0.783031225 0 2.02329509e-05)
    list(5.04025e-09 0.783031205 0 1.92655523e-05)
    list(5.04225e-09 0.783031189 0 1.87689504e-05)
    list(5.04425e-09 0.783031174 0 1.84654062e-05)
    list(5.04625e-09 0.78303116 0 1.8253532e-05)
    list(5.04825e-09 0.783031147 0 1.80950592e-05)
    list(5.05025e-09 0.783031135 0 1.79734157e-05)
    list(5.05225e-09 0.783031123 0 1.78793629e-05)
    list(5.05425e-09 0.783031111 0 1.78064812e-05)
    list(5.05625e-09 0.7830311 0 1.77498517e-05)
    list(5.05825e-09 0.783031089 0 1.77056282e-05)
    list(5.06025e-09 0.783031077 0 1.76708238e-05)
    list(5.06225e-09 0.783031066 0 1.7643149e-05)
    list(5.06425e-09 0.783031055 0 1.76208715e-05)
    list(5.06625e-09 0.783031044 0 1.76026931e-05)
    list(5.06825e-09 0.783031033 0 1.75876473e-05)
    list(5.07025e-09 0.783031022 0 1.75750168e-05)
    list(5.07225e-09 0.783031011 0 1.75642691e-05)
    list(5.07425e-09 0.783031 0 1.75550079e-05)
    list(5.07625e-09 0.783030989 0 1.75469365e-05)
    list(5.07825e-09 0.783030978 0 1.75398311e-05)
    list(5.08025e-09 0.783030967 0 1.75335211e-05)
    list(5.08225e-09 0.783030956 0 1.75278753e-05)
    list(5.08425e-09 0.783030945 0 1.75227912e-05)
    list(5.08625e-09 0.783030934 0 1.75181878e-05)
    list(5.08825e-09 0.783030923 0 1.75140002e-05)
    list(5.09025e-09 0.783030912 0 1.75101756e-05)
    list(5.09225e-09 0.783030901 0 1.75066707e-05)
    list(5.09425e-09 0.78303089 0 1.7503449e-05)
    list(5.09625e-09 0.783030879 0 1.75004801e-05)
    list(5.09825e-09 0.783030868 0 1.74977378e-05)
    list(5.1e-09 0.783030859 0 1.74946013e-05)
    list(5.10075e-09 0.783017091 0.15 2.73371483e-05)
    list(5.10275e-09 0.782972733 0.55 6.01147559e-05)
    list(5.10475e-09 0.783148411 0.95 8.60191077e-05)
    list(5.10535e-09 0.783227329 1 4.40308522e-05)
    list(5.10725e-09 0.783487386 1 3.90946401e-05)
    list(5.10925e-09 0.783738259 1 3.72239631e-05)
    list(5.11125e-09 0.783980191 1 3.63759524e-05)
    list(5.11325e-09 0.784218137 1 3.59248735e-05)
    list(5.11525e-09 0.784453848 1 3.56493098e-05)
    list(5.11725e-09 0.784688028 1 3.54616727e-05)
    list(5.11925e-09 0.784921023 1 3.5322776e-05)
    list(5.12125e-09 0.785153032 1 3.5212928e-05)
    list(5.12325e-09 0.785384193 1 3.51212869e-05)
    list(5.12525e-09 0.785614607 1 3.50414919e-05)
    list(5.12725e-09 0.785844351 1 3.49696508e-05)
    list(5.12925e-09 0.786073489 1 3.49033109e-05)
    list(5.13015e-09 0.786184738 0.97 -8.64221436e-07)
    list(5.13175e-09 0.786431067 0.65 -1.79235711e-05)
    list(5.13375e-09 0.786549115 0.25 -1.50650058e-05)
    list(5.13505e-09 0.786576648 0 2.22032528e-05)
    list(5.13625e-09 0.786576622 0 2.23048044e-05)
    list(5.13825e-09 0.786576593 0 2.02181709e-05)
    list(5.14025e-09 0.786576574 0 1.92459507e-05)
    list(5.14225e-09 0.786576557 0 1.87474995e-05)
    list(5.14425e-09 0.786576543 0 1.84446918e-05)
    list(5.14625e-09 0.786576529 0 1.82352144e-05)
    list(5.14825e-09 0.786576516 0 1.80798185e-05)
    list(5.15025e-09 0.786576503 0 1.79612261e-05)
    list(5.15225e-09 0.786576491 0 1.78698346e-05)
    list(5.15425e-09 0.786576479 0 1.77991096e-05)
    list(5.15625e-09 0.786576468 0 1.77441514e-05)
    list(5.15825e-09 0.786576456 0 1.7701186e-05)
    list(5.16025e-09 0.786576445 0 1.76673103e-05)
    list(5.16225e-09 0.786576434 0 1.7640312e-05)
    list(5.16425e-09 0.786576423 0 1.76185228e-05)
    list(5.16625e-09 0.786576411 0 1.76006951e-05)
    list(5.16825e-09 0.7865764 0 1.75859005e-05)
    list(5.17025e-09 0.786576389 0 1.75734501e-05)
    list(5.17225e-09 0.786576378 0 1.75628322e-05)
    list(5.17425e-09 0.786576367 0 1.75536652e-05)
    list(5.17625e-09 0.786576356 0 1.75456631e-05)
    list(5.17825e-09 0.786576345 0 1.75386096e-05)
    list(5.18025e-09 0.786576333 0 1.75323396e-05)
    list(5.18225e-09 0.786576322 0 1.75267254e-05)
    list(5.18425e-09 0.786576311 0 1.75216673e-05)
    list(5.18625e-09 0.7865763 0 1.7517086e-05)
    list(5.18825e-09 0.786576289 0 1.75129179e-05)
    list(5.19025e-09 0.786576278 0 1.75091111e-05)
    list(5.19225e-09 0.786576267 0 1.75056227e-05)
    list(5.19425e-09 0.786576256 0 1.75024169e-05)
    list(5.19625e-09 0.786576244 0 1.74994632e-05)
    list(5.19825e-09 0.786576233 0 1.74967359e-05)
    list(5.2e-09 0.786576224 0 1.74936173e-05)
    list(5.20075e-09 0.786562259 0.15 2.73448273e-05)
    list(5.20275e-09 0.786517287 0.55 5.99750267e-05)
    list(5.20475e-09 0.786688 0.95 8.5001726e-05)
    list(5.20535e-09 0.786764488 1 4.3199259e-05)
    list(5.20725e-09 0.787019261 1 3.85157691e-05)
    list(5.20925e-09 0.787266225 1 3.67380363e-05)
    list(5.21125e-09 0.787504877 1 3.59224079e-05)
    list(5.21325e-09 0.787739784 1 3.54837371e-05)
    list(5.21525e-09 0.787972557 1 3.52139136e-05)
    list(5.21725e-09 0.788203852 1 3.50296657e-05)
    list(5.21925e-09 0.788433988 1 3.4893209e-05)
    list(5.22125e-09 0.788663158 1 3.47853202e-05)
    list(5.22325e-09 0.788891494 1 3.4695329e-05)
    list(5.22525e-09 0.789119093 1 3.46169515e-05)
    list(5.22725e-09 0.789346031 1 3.45463402e-05)
    list(5.22925e-09 0.789572371 1 3.44810743e-05)
    list(5.23015e-09 0.789682422 0.97 -1.2300345e-06)
    list(5.23175e-09 0.789928941 0.65 -1.80042695e-05)
    list(5.23375e-09 0.790048199 0.25 -1.50300448e-05)
    list(5.23505e-09 0.790076085 0 2.22027216e-05)
    list(5.23625e-09 0.790076059 0 2.229739e-05)
    list(5.23825e-09 0.79007603 0 2.02029843e-05)
    list(5.24025e-09 0.79007601 0 1.92261095e-05)
    list(5.24225e-09 0.790075993 0 1.87260813e-05)
    list(5.24425e-09 0.790075979 0 1.84242399e-05)
    list(5.24625e-09 0.790075965 0 1.8217283e-05)
    list(5.24825e-09 0.790075951 0 1.80649894e-05)
    list(5.25025e-09 0.790075939 0 1.7949413e-05)
    list(5.25225e-09 0.790075927 0 1.78606228e-05)
    list(5.25425e-09 0.790075915 0 1.77919918e-05)
    list(5.25625e-09 0.790075903 0 1.77386492e-05)
    list(5.25825e-09 0.790075892 0 1.76968965e-05)
    list(5.26025e-09 0.79007588 0 1.76639141e-05)
    list(5.26225e-09 0.790075869 0 1.76375657e-05)
    list(5.26425e-09 0.790075857 0 1.76162454e-05)
    list(5.26625e-09 0.790075846 0 1.75987541e-05)
    list(5.26825e-09 0.790075835 0 1.75842005e-05)
    list(5.27025e-09 0.790075824 0 1.7571923e-05)
    list(5.27225e-09 0.790075812 0 1.75614296e-05)
    list(5.27425e-09 0.790075801 0 1.75523532e-05)
    list(5.27625e-09 0.79007579 0 1.75444178e-05)
    list(5.27825e-09 0.790075779 0 1.75374145e-05)
    list(5.28025e-09 0.790075767 0 1.75311831e-05)
    list(5.28225e-09 0.790075756 0 1.75255996e-05)
    list(5.28425e-09 0.790075745 0 1.75205668e-05)
    list(5.28625e-09 0.790075733 0 1.75160071e-05)
    list(5.28825e-09 0.790075722 0 1.75118581e-05)
    list(5.29025e-09 0.790075711 0 1.75080687e-05)
    list(5.29225e-09 0.7900757 0 1.75045966e-05)
    list(5.29425e-09 0.790075688 0 1.75014062e-05)
    list(5.29625e-09 0.790075677 0 1.74984676e-05)
    list(5.29825e-09 0.790075666 0 1.7495755e-05)
    list(5.3e-09 0.790075656 0 1.74926542e-05)
    list(5.30075e-09 0.790061497 0.15 2.73524412e-05)
    list(5.30275e-09 0.790015921 0.55 5.98333671e-05)
    list(5.30475e-09 0.79018163 0.95 8.39916217e-05)
    list(5.30535e-09 0.790255711 1 4.23751693e-05)
    list(5.30725e-09 0.790505257 1 3.79423644e-05)
    list(5.30925e-09 0.790748351 1 3.62555793e-05)
    list(5.31125e-09 0.790983747 1 3.54712309e-05)
    list(5.31325e-09 0.791215631 1 3.50444453e-05)
    list(5.31525e-09 0.791445481 1 3.47801201e-05)
    list(5.31725e-09 0.7916739 1 3.45991423e-05)
    list(5.31925e-09 0.791901188 1 3.44650586e-05)
    list(5.32125e-09 0.792127529 1 3.43590851e-05)
    list(5.32325e-09 0.792353048 1 3.42707116e-05)
    list(5.32525e-09 0.792577841 1 3.41937264e-05)
    list(5.32725e-09 0.792801981 1 3.41243247e-05)
    list(5.32925e-09 0.793025531 1 3.40601163e-05)
    list(5.33015e-09 0.79313439 0.97 -1.59446587e-06)
    list(5.33175e-09 0.793381067 0.65 -1.80817428e-05)
    list(5.33375e-09 0.793501531 0.25 -1.49976889e-05)
    list(5.33505e-09 0.793529765 0 2.22018968e-05)
    list(5.33625e-09 0.793529738 0 2.22896112e-05)
    list(5.33825e-09 0.793529709 0 2.0187401e-05)
    list(5.34025e-09 0.793529689 0 1.92060606e-05)
    list(5.34225e-09 0.793529673 0 1.87047298e-05)
    list(5.34425e-09 0.793529658 0 1.84040741e-05)
    list(5.34625e-09 0.793529644 0 1.8199749e-05)
    list(5.34825e-09 0.79352963 0 1.80505743e-05)
    list(5.35025e-09 0.793529618 0 1.79379748e-05)
    list(5.35225e-09 0.793529605 0 1.78517254e-05)
    list(5.35425e-09 0.793529593 0 1.77851267e-05)
    list(5.35625e-09 0.793529582 0 1.77333457e-05)
    list(5.35825e-09 0.79352957 0 1.76927619e-05)
    list(5.36025e-09 0.793529558 0 1.76606391e-05)
    list(5.36225e-09 0.793529547 0 1.76349152e-05)
    list(5.36425e-09 0.793529535 0 1.76140449e-05)
    list(5.36625e-09 0.793529524 0 1.75968765e-05)
    list(5.36825e-09 0.793529513 0 1.75825543e-05)
    list(5.37025e-09 0.793529501 0 1.75704427e-05)
    list(5.37225e-09 0.79352949 0 1.7560069e-05)
    list(5.37425e-09 0.793529478 0 1.75510796e-05)
    list(5.37625e-09 0.793529467 0 1.75432085e-05)
    list(5.37825e-09 0.793529456 0 1.75362535e-05)
    list(5.38025e-09 0.793529444 0 1.75300595e-05)
    list(5.38225e-09 0.793529433 0 1.75245058e-05)
    list(5.38425e-09 0.793529421 0 1.75194976e-05)
    list(5.38625e-09 0.79352941 0 1.75149589e-05)
    list(5.38825e-09 0.793529399 0 1.75108285e-05)
    list(5.39025e-09 0.793529387 0 1.75070561e-05)
    list(5.39225e-09 0.793529376 0 1.75035999e-05)
    list(5.39425e-09 0.793529364 0 1.75004248e-05)
    list(5.39625e-09 0.793529353 0 1.74975009e-05)
    list(5.39825e-09 0.793529341 0 1.74948026e-05)
    list(5.4e-09 0.793529331 0 1.74917191e-05)
    list(5.40075e-09 0.793514978 0.15 2.73599876e-05)
    list(5.40275e-09 0.793468812 0.55 5.96896756e-05)
    list(5.40475e-09 0.793629479 0.95 8.2990103e-05)
    list(5.40535e-09 0.793701176 1 4.15587562e-05)
    list(5.40725e-09 0.793945554 1 3.73744654e-05)
    list(5.40925e-09 0.794184818 1 3.57766302e-05)
    list(5.41125e-09 0.794416982 1 3.50224901e-05)
    list(5.41325e-09 0.794645861 1 3.46070911e-05)
    list(5.41525e-09 0.7948728 1 3.43480368e-05)
    list(5.41725e-09 0.795098355 1 3.41702178e-05)
    list(5.41925e-09 0.795322806 1 3.40384448e-05)
    list(5.42125e-09 0.795546327 1 3.39343457e-05)
    list(5.42325e-09 0.79576904 1 3.38475598e-05)
    list(5.42525e-09 0.795991036 1 3.37719434e-05)
    list(5.42725e-09 0.796212389 1 3.37037322e-05)
    list(5.42925e-09 0.796433157 1 3.3640566e-05)
    list(5.43015e-09 0.796540828 0.97 -1.95740824e-06)
    list(5.43175e-09 0.796787634 0.65 -1.81564553e-05)
    list(5.43375e-09 0.796909298 0.25 -1.49690329e-05)
    list(5.43505e-09 0.796937876 0 2.22007636e-05)
    list(5.43625e-09 0.796937849 0 2.22814566e-05)
    list(5.43825e-09 0.79693782 0 2.0171434e-05)
    list(5.44025e-09 0.7969378 0 1.91858363e-05)
    list(5.44225e-09 0.796937783 0 1.86834776e-05)
    list(5.44425e-09 0.796937768 0 1.83842159e-05)
    list(5.44625e-09 0.796937754 0 1.81826216e-05)
    list(5.44825e-09 0.79693774 0 1.80365742e-05)
    list(5.45025e-09 0.796937728 0 1.79269091e-05)
    list(5.45225e-09 0.796937715 0 1.78431395e-05)
    list(5.45425e-09 0.796937703 0 1.77785126e-05)
    list(5.45625e-09 0.796937691 0 1.77282408e-05)
    list(5.45825e-09 0.796937679 0 1.76887837e-05)
    list(5.46025e-09 0.796937668 0 1.76574881e-05)
    list(5.46225e-09 0.796937656 0 1.76323644e-05)
    list(5.46425e-09 0.796937644 0 1.76119264e-05)
    list(5.46625e-09 0.796937633 0 1.75950681e-05)
    list(5.46825e-09 0.796937621 0 1.75809679e-05)
    list(5.47025e-09 0.79693761 0 1.75690157e-05)
    list(5.47225e-09 0.796937598 0 1.75587569e-05)
    list(5.47425e-09 0.796937587 0 1.75498513e-05)
    list(5.47625e-09 0.796937575 0 1.7542042e-05)
    list(5.47825e-09 0.796937564 0 1.75351337e-05)
    list(5.48025e-09 0.796937552 0 1.75289757e-05)
    list(5.48225e-09 0.79693754 0 1.75234509e-05)
    list(5.48425e-09 0.796937529 0 1.75184664e-05)
    list(5.48625e-09 0.796937517 0 1.75139482e-05)
    list(5.48825e-09 0.796937506 0 1.75098359e-05)
    list(5.49025e-09 0.796937494 0 1.750608e-05)
    list(5.49225e-09 0.796937483 0 1.75026393e-05)
    list(5.49425e-09 0.796937471 0 1.74994789e-05)
    list(5.49625e-09 0.79693746 0 1.74965694e-05)
    list(5.49825e-09 0.796937448 0 1.74938851e-05)
    list(5.5e-09 0.796937438 0 1.74908185e-05)
    list(5.50075e-09 0.796922892 0.15 2.73674644e-05)
    list(5.50275e-09 0.796876145 0.55 5.95438487e-05)
    list(5.50475e-09 0.797031738 0.95 8.19983619e-05)
    list(5.50535e-09 0.797101075 1 4.0750176e-05)
    list(5.50725e-09 0.797340343 1 3.68121058e-05)
    list(5.50925e-09 0.797575816 1 3.53012254e-05)
    list(5.51125e-09 0.797804774 1 3.45762528e-05)
    list(5.51325e-09 0.798030665 1 3.41717655e-05)
    list(5.51525e-09 0.798254708 1 3.39177686e-05)
    list(5.51725e-09 0.798477412 1 3.37430049e-05)
    list(5.51925e-09 0.798699037 1 3.36134844e-05)
    list(5.52125e-09 0.79891975 1 3.35112216e-05)
    list(5.52325e-09 0.799139667 1 3.34259953e-05)
    list(5.52525e-09 0.799358877 1 3.33517256e-05)
    list(5.52725e-09 0.799577452 1 3.32846872e-05)
    list(5.52925e-09 0.79979545 1 3.32225489e-05)
    list(5.53015e-09 0.799901935 0.97 -2.31876444e-06)
    list(5.53175e-09 0.800148842 0.65 -1.82288388e-05)
    list(5.53375e-09 0.800271699 0.25 -1.49450043e-05)
    list(5.53505e-09 0.800300618 0 2.2199308e-05)
    list(5.53625e-09 0.800300591 0 2.22729169e-05)
    list(5.53825e-09 0.800300561 0 2.01550993e-05)
    list(5.54025e-09 0.800300541 0 1.91654694e-05)
    list(5.54225e-09 0.800300524 0 1.86623554e-05)
    list(5.54425e-09 0.800300509 0 1.83646846e-05)
    list(5.54625e-09 0.800300495 0 1.81659079e-05)
    list(5.54825e-09 0.800300481 0 1.80229885e-05)
    list(5.55025e-09 0.800300468 0 1.79162121e-05)
    list(5.55225e-09 0.800300456 0 1.78348615e-05)
    list(5.55425e-09 0.800300444 0 1.77721469e-05)
    list(5.55625e-09 0.800300432 0 1.77233336e-05)
    list(5.55825e-09 0.80030042 0 1.76849628e-05)
    list(5.56025e-09 0.800300408 0 1.76544632e-05)
    list(5.56225e-09 0.800300396 0 1.76299165e-05)
    list(5.56425e-09 0.800300384 0 1.76098938e-05)
    list(5.56625e-09 0.800300373 0 1.75933332e-05)
    list(5.56825e-09 0.800300361 0 1.75794463e-05)
    list(5.57025e-09 0.800300349 0 1.75676471e-05)
    list(5.57225e-09 0.800300338 0 1.75574989e-05)
    list(5.57425e-09 0.800300326 0 1.75486737e-05)
    list(5.57625e-09 0.800300314 0 1.75409241e-05)
    list(5.57825e-09 0.800300302 0 1.75340607e-05)
    list(5.58025e-09 0.800300291 0 1.75279376e-05)
    list(5.58225e-09 0.800300279 0 1.75224405e-05)
    list(5.58425e-09 0.800300267 0 1.75174791e-05)
    list(5.58625e-09 0.800300256 0 1.75129806e-05)
    list(5.58825e-09 0.800300244 0 1.75088858e-05)
    list(5.59025e-09 0.800300232 0 1.7505146e-05)
    list(5.59225e-09 0.800300221 0 1.75017203e-05)
    list(5.59425e-09 0.800300209 0 1.74985743e-05)
    list(5.59625e-09 0.800300197 0 1.74956785e-05)
    list(5.59825e-09 0.800300186 0 1.74930078e-05)
    list(5.6e-09 0.800300175 0 1.74899575e-05)
    list(5.60075e-09 0.800285438 0.15 2.73748695e-05)
    list(5.60275e-09 0.800238122 0.55 5.93957816e-05)
    list(5.60475e-09 0.800388609 0.95 8.10174547e-05)
    list(5.60535e-09 0.80045561 1 3.99495706e-05)
    list(5.60725e-09 0.800689828 1 3.62553142e-05)
    list(5.60925e-09 0.800921551 1 3.48294005e-05)
    list(5.61125e-09 0.801147327 1 3.41325859e-05)
    list(5.61325e-09 0.801370249 1 3.37385582e-05)
    list(5.61525e-09 0.801591411 1 3.34894182e-05)
    list(5.61725e-09 0.801811276 1 3.33176134e-05)
    list(5.61925e-09 0.802030088 1 3.31902916e-05)
    list(5.62125e-09 0.802248004 1 3.30898296e-05)
    list(5.62325e-09 0.802465136 1 3.30061365e-05)
    list(5.62525e-09 0.802681572 1 3.29331929e-05)
    list(5.62725e-09 0.80289738 1 3.28673109e-05)
    list(5.62925e-09 0.803112618 1 3.28061871e-05)
    list(5.63015e-09 0.803217924 0.97 -2.67844698e-06)
    list(5.63175e-09 0.803464905 0.65 -1.82992905e-05)
    list(5.63375e-09 0.803588947 0.25 -1.49263577e-05)
    list(5.63505e-09 0.803618203 0 2.21975172e-05)
    list(5.63625e-09 0.803618175 0 2.22639853e-05)
    list(5.63825e-09 0.803618145 0 2.01384152e-05)
    list(5.64025e-09 0.803618124 0 1.91449926e-05)
    list(5.64225e-09 0.803618107 0 1.86413923e-05)
    list(5.64425e-09 0.803618092 0 1.83454968e-05)
    list(5.64625e-09 0.803618078 0 1.81496131e-05)
    list(5.64825e-09 0.803618064 0 1.80098152e-05)
    list(5.65025e-09 0.803618051 0 1.79058793e-05)
    list(5.65225e-09 0.803618039 0 1.78268868e-05)
    list(5.65425e-09 0.803618026 0 1.77660266e-05)
    list(5.65625e-09 0.803618014 0 1.77186226e-05)
    list(5.65825e-09 0.803618002 0 1.7681299e-05)
    list(5.66025e-09 0.80361799 0 1.76515656e-05)
    list(5.66225e-09 0.803617978 0 1.76275737e-05)
    list(5.66425e-09 0.803617967 0 1.76079501e-05)
    list(5.66625e-09 0.803617955 0 1.75916755e-05)
    list(5.66825e-09 0.803617943 0 1.75779934e-05)
    list(5.67025e-09 0.803617931 0 1.75663413e-05)
    list(5.67225e-09 0.803617919 0 1.75562992e-05)
    list(5.67425e-09 0.803617907 0 1.75475516e-05)
    list(5.67625e-09 0.803617896 0 1.75398592e-05)
    list(5.67825e-09 0.803617884 0 1.75330391e-05)
    list(5.68025e-09 0.803617872 0 1.75269496e-05)
    list(5.68225e-09 0.80361786 0 1.75214794e-05)
    list(5.68425e-09 0.803617848 0 1.75165402e-05)
    list(5.68625e-09 0.803617836 0 1.75120608e-05)
    list(5.68825e-09 0.803617825 0 1.75079829e-05)
    list(5.69025e-09 0.803617813 0 1.75042585e-05)
    list(5.69225e-09 0.803617801 0 1.75008473e-05)
    list(5.69425e-09 0.803617789 0 1.74977151e-05)
    list(5.69625e-09 0.803617777 0 1.74948327e-05)
    list(5.69825e-09 0.803617766 0 1.7492175e-05)
    list(5.7e-09 0.803617755 0 1.74891403e-05)
    list(5.70075e-09 0.803602827 0.15 2.7382201e-05)
    list(5.70275e-09 0.803554952 0.55 5.92453686e-05)
    list(5.70475e-09 0.803700306 0.95 8.00482877e-05)
    list(5.70535e-09 0.803764997 1 3.91570698e-05)
    list(5.70725e-09 0.803994225 1 3.5704116e-05)
    list(5.70925e-09 0.804222237 1 3.43611913e-05)
    list(5.71125e-09 0.804444858 1 3.36915563e-05)
    list(5.71325e-09 0.804664829 1 3.33075581e-05)
    list(5.71525e-09 0.804883124 1 3.30630867e-05)
    list(5.71725e-09 0.805100165 1 3.28941511e-05)
    list(5.71925e-09 0.805316177 1 3.27689777e-05)
    list(5.72125e-09 0.805531309 1 3.26702833e-05)
    list(5.72325e-09 0.805745669 1 3.25880991e-05)
    list(5.72525e-09 0.805959342 1 3.25164623e-05)
    list(5.72725e-09 0.806172395 1 3.24517211e-05)
    list(5.72925e-09 0.806384885 1 3.23915994e-05)
    list(5.73015e-09 0.806489016 0.97 -3.03637757e-06)
    list(5.73175e-09 0.806736044 0.65 -1.83681734e-05)
    list(5.73375e-09 0.806861264 0.25 -1.49136742e-05)
    list(5.73505e-09 0.806890852 0 2.21953799e-05)
    list(5.73625e-09 0.806890824 0 2.22546571e-05)
    list(5.73825e-09 0.806890794 0 2.01214022e-05)
    list(5.74025e-09 0.806890773 0 1.91244382e-05)
    list(5.74225e-09 0.806890756 0 1.86206151e-05)
    list(5.74425e-09 0.806890741 0 1.8326667e-05)
    list(5.74625e-09 0.806890726 0 1.81337403e-05)
    list(5.74825e-09 0.806890713 0 1.79970512e-05)
    list(5.75025e-09 0.8068907 0 1.78959052e-05)
    list(5.75225e-09 0.806890687 0 1.78192103e-05)
    list(5.75425e-09 0.806890674 0 1.77601477e-05)
    list(5.75625e-09 0.806890662 0 1.77141054e-05)
    list(5.75825e-09 0.80689065 0 1.76777913e-05)
    list(5.76025e-09 0.806890638 0 1.76487955e-05)
    list(5.76225e-09 0.806890626 0 1.76253372e-05)
    list(5.76425e-09 0.806890614 0 1.76060972e-05)
    list(5.76625e-09 0.806890602 0 1.75900974e-05)
    list(5.76825e-09 0.80689059 0 1.75766121e-05)
    list(5.77025e-09 0.806890578 0 1.75651013e-05)
    list(5.77225e-09 0.806890566 0 1.75551612e-05)
    list(5.77425e-09 0.806890554 0 1.7546488e-05)
    list(5.77625e-09 0.806890542 0 1.75388508e-05)
    list(5.77825e-09 0.80689053 0 1.75320724e-05)
    list(5.78025e-09 0.806890518 0 1.75260152e-05)
    list(5.78225e-09 0.806890506 0 1.75205709e-05)
    list(5.78425e-09 0.806890494 0 1.75156531e-05)
    list(5.78625e-09 0.806890482 0 1.75111921e-05)
    list(5.78825e-09 0.80689047 0 1.75071305e-05)
    list(5.79025e-09 0.806890458 0 1.7503421e-05)
    list(5.79225e-09 0.806890446 0 1.75000236e-05)
    list(5.79425e-09 0.806890434 0 1.74969046e-05)
    list(5.79625e-09 0.806890422 0 1.7494035e-05)
    list(5.79825e-09 0.80689041 0 1.74913897e-05)
    list(5.8e-09 0.8068904 1.65436123e-13 1.74883701e-05)
    list(5.80075e-09 0.806875283 0.15 2.73894572e-05)
    list(5.80275e-09 0.806826859 0.55 5.90925043e-05)
    list(5.80475e-09 0.806967054 0.95 7.90916067e-05)
    list(5.80535e-09 0.807029461 1 3.8372793e-05)
    list(5.80725e-09 0.807253759 1 3.51585342e-05)
    list(5.80925e-09 0.807478101 1 3.38966344e-05)
    list(5.81125e-09 0.807697592 1 3.32532314e-05)
    list(5.81325e-09 0.807914631 1 3.28788535e-05)
    list(5.81525e-09 0.808130077 1 3.2638874e-05)
    list(5.81725e-09 0.808344308 1 3.24727236e-05)
    list(5.81925e-09 0.808557533 1 3.23496519e-05)
    list(5.82125e-09 0.808769894 1 3.22526942e-05)
    list(5.82325e-09 0.808981495 1 3.21719956e-05)
    list(5.82525e-09 0.809192418 1 3.21016476e-05)
    list(5.82725e-09 0.809402729 1 3.20380326e-05)
    list(5.82925e-09 0.809612483 1 3.19789014e-05)
    list(5.83015e-09 0.809715445 0.97 -3.39248654e-06)
    list(5.83175e-09 0.809962495 0.65 -1.84358164e-05)
    list(5.83375e-09 0.810088884 0.25 -1.49073646e-05)
    list(5.83505e-09 0.8101188 0 2.21928857e-05)
    list(5.83625e-09 0.810118772 0 2.22449305e-05)
    list(5.83825e-09 0.810118741 0 2.01040827e-05)
    list(5.84025e-09 0.81011872 0 1.91038379e-05)
    list(5.84225e-09 0.810118703 0 1.86000486e-05)
    list(5.84425e-09 0.810118688 0 1.83082072e-05)
    list(5.84625e-09 0.810118673 0 1.81182907e-05)
    list(5.84825e-09 0.81011866 0 1.79846916e-05)
    list(5.85025e-09 0.810118646 0 1.78862834e-05)
    list(5.85225e-09 0.810118634 0 1.78118258e-05)
    list(5.85425e-09 0.810118621 0 1.77545054e-05)
    list(5.85625e-09 0.810118609 0 1.77097788e-05)
    list(5.85825e-09 0.810118596 0 1.7674438e-05)
    list(5.86025e-09 0.810118584 0 1.76461523e-05)
    list(5.86225e-09 0.810118572 0 1.76232072e-05)
    list(5.86425e-09 0.81011856 0 1.76043359e-05)
    list(5.86625e-09 0.810118548 0 1.75886001e-05)
    list(5.86825e-09 0.810118536 0 1.75753039e-05)
    list(5.87025e-09 0.810118523 0 1.75639289e-05)
    list(5.87225e-09 0.810118511 0 1.7554087e-05)
    list(5.87425e-09 0.810118499 0 1.75454854e-05)
    list(5.87625e-09 0.810118487 0 1.75379012e-05)
    list(5.87825e-09 0.810118475 0 1.75311629e-05)
    list(5.88025e-09 0.810118463 0 1.75251368e-05)
    list(5.88225e-09 0.810118451 0 1.75197174e-05)
    list(5.88425e-09 0.810118439 0 1.75148202e-05)
    list(5.88625e-09 0.810118427 0 1.75103767e-05)
    list(5.88825e-09 0.810118415 0 1.75063308e-05)
    list(5.89025e-09 0.810118403 0 1.75026355e-05)
    list(5.89225e-09 0.81011839 0 1.74992514e-05)
    list(5.89425e-09 0.810118378 0 1.74961451e-05)
    list(5.89625e-09 0.810118366 0 1.74932876e-05)
    list(5.89825e-09 0.810118354 0 1.74906542e-05)
    list(5.9e-09 0.810118344 0 1.74876488e-05)
    list(5.90075e-09 0.81010304 0.15 2.73966364e-05)
    list(5.90275e-09 0.810054075 0.55 5.89370845e-05)
    list(5.90475e-09 0.810189091 0.95 7.81479908e-05)
    list(5.90535e-09 0.810249239 1 3.75968512e-05)
    list(5.90725e-09 0.810468668 1 3.46185904e-05)
    list(5.90925e-09 0.810689379 1 3.34357675e-05)
    list(5.91125e-09 0.810905768 1 3.28176794e-05)
    list(5.91325e-09 0.811119894 1 3.24525325e-05)
    list(5.91525e-09 0.811332507 1 3.22168785e-05)
    list(5.91725e-09 0.811543943 1 3.2053435e-05)
    list(5.91925e-09 0.811754396 1 3.1932421e-05)
    list(5.92125e-09 0.811964 1 3.18371709e-05)
    list(5.92325e-09 0.812172856 1 3.17579362e-05)
    list(5.92525e-09 0.812381043 1 3.16888597e-05)
    list(5.92725e-09 0.812588625 1 3.16263573e-05)
    list(5.92925e-09 0.812795657 1 3.15682054e-05)
    list(5.93015e-09 0.812897455 0.97 -3.74671216e-06)
    list(5.93175e-09 0.813144502 0.65 -1.85025155e-05)
    list(5.93375e-09 0.813272051 0.25 -1.49076768e-05)
    list(5.93505e-09 0.813302291 0 2.21900263e-05)
    list(5.93625e-09 0.813302262 0 2.22348059e-05)
    list(5.93825e-09 0.813302232 0 2.00864803e-05)
    list(5.94025e-09 0.813302211 0 1.90832221e-05)
    list(5.94225e-09 0.813302194 0 1.85797154e-05)
    list(5.94425e-09 0.813302178 0 1.82901272e-05)
    list(5.94625e-09 0.813302163 0 1.81032639e-05)
    list(5.94825e-09 0.81330215 0 1.79727308e-05)
    list(5.95025e-09 0.813302136 0 1.78770064e-05)
    list(5.95225e-09 0.813302123 0 1.78047265e-05)
    list(5.95425e-09 0.813302111 0 1.77490944e-05)
    list(5.95625e-09 0.813302098 0 1.77056388e-05)
    list(5.95825e-09 0.813302086 0 1.76712365e-05)
    list(5.96025e-09 0.813302073 0 1.76436345e-05)
    list(5.96225e-09 0.813302061 0 1.76211831e-05)
    list(5.96425e-09 0.813302049 0 1.76026661e-05)
    list(5.96625e-09 0.813302037 0 1.75871842e-05)
    list(5.96825e-09 0.813302024 0 1.75740697e-05)
    list(5.97025e-09 0.813302012 0 1.75628252e-05)
    list(5.97225e-09 0.813302 0 1.75530776e-05)
    list(5.97425e-09 0.813301988 0 1.75445448e-05)
    list(5.97625e-09 0.813301975 0 1.75370116e-05)
    list(5.97825e-09 0.813301963 0 1.75303118e-05)
    list(5.98025e-09 0.813301951 0 1.75243156e-05)
    list(5.98225e-09 0.813301939 0 1.751892e-05)
    list(5.98425e-09 0.813301926 0 1.75140426e-05)
    list(5.98625e-09 0.813301914 0 1.7509616e-05)
    list(5.98825e-09 0.813301902 0 1.7505585e-05)
    list(5.99025e-09 0.81330189 0 1.75019033e-05)
    list(5.99225e-09 0.813301878 0 1.74985319e-05)
    list(5.99425e-09 0.813301865 0 1.74954376e-05)
    list(5.99625e-09 0.813301853 0 1.74925917e-05)
    list(5.99825e-09 0.813301841 0 1.74899695e-05)
    list(6e-09 0.81330183 0 1.74869776e-05)
    list(6.00075e-09 0.81328634 0.15 2.74037372e-05)
    list(6.00275e-09 0.813236843 0.55 5.87790069e-05)
    list(6.00475e-09 0.813366662 0.95 7.72178514e-05)
    list(6.00535e-09 0.813424579 1 3.68293475e-05)
    list(6.00725e-09 0.8136392 1 3.40843053e-05)
    list(6.00925e-09 0.81385632 1 3.29786301e-05)
    list(6.01125e-09 0.814069632 1 3.23849695e-05)
    list(6.01325e-09 0.814280867 1 3.20286829e-05)
    list(6.01525e-09 0.814490663 1 3.17971979e-05)
    list(6.01725e-09 0.814699321 1 3.16363876e-05)
    list(6.01925e-09 0.814907017 1 3.15173902e-05)
    list(6.02125e-09 0.815113879 1 3.14238198e-05)
    list(6.02325e-09 0.815320004 1 3.13460284e-05)
    list(6.02525e-09 0.815525468 1 3.1278207e-05)
    list(6.02725e-09 0.815730336 1 3.1216804e-05)
    list(6.02925e-09 0.81593466 1 3.11596209e-05)
    list(6.03015e-09 0.8160353 0.97 -4.09899991e-06)
    list(6.03175e-09 0.81628232 0.65 -1.85685353e-05)
    list(6.03375e-09 0.81641102 0.25 -1.49147064e-05)
    list(6.03505e-09 0.81644158 0 2.21867946e-05)
    list(6.03625e-09 0.816441551 0 2.22242863e-05)
    list(6.03825e-09 0.81644152 0 2.00686198e-05)
    list(6.04025e-09 0.816441499 0 1.90626205e-05)
    list(6.04225e-09 0.816441481 0 1.85596357e-05)
    list(6.04425e-09 0.816441466 0 1.82724344e-05)
    list(6.04625e-09 0.816441451 0 1.80886578e-05)
    list(6.04825e-09 0.816441437 0 1.79611618e-05)
    list(6.05025e-09 0.816441424 0 1.78680663e-05)
    list(6.05225e-09 0.816441411 0 1.77979051e-05)
    list(6.05425e-09 0.816441398 0 1.77439085e-05)
    list(6.05625e-09 0.816441385 0 1.77016808e-05)
    list(6.05825e-09 0.816441373 0 1.76681833e-05)
    list(6.06025e-09 0.81644136 0 1.76412396e-05)
    list(6.06225e-09 0.816441348 0 1.76192631e-05)
    list(6.06425e-09 0.816441336 0 1.7601087e-05)
    list(6.06625e-09 0.816441323 0 1.7585849e-05)
    list(6.06825e-09 0.816441311 0 1.75729092e-05)
    list(6.07025e-09 0.816441298 0 1.75617901e-05)
    list(6.07225e-09 0.816441286 0 1.7552133e-05)
    list(6.07425e-09 0.816441274 0 1.75436664e-05)
    list(6.07625e-09 0.816441261 0 1.75361821e-05)
    list(6.07825e-09 0.816441249 0 1.75295194e-05)
    list(6.08025e-09 0.816441236 0 1.75235518e-05)
    list(6.08225e-09 0.816441224 0 1.75181791e-05)
    list(6.08425e-09 0.816441212 0 1.75133206e-05)
    list(6.08625e-09 0.816441199 0 1.75089101e-05)
    list(6.08825e-09 0.816441187 0 1.75048934e-05)
    list(6.09025e-09 0.816441175 0 1.75012246e-05)
    list(6.09225e-09 0.816441162 0 1.74978652e-05)
    list(6.09425e-09 0.81644115 0 1.74947823e-05)
    list(6.09625e-09 0.816441137 0 1.74919474e-05)
    list(6.09825e-09 0.816441125 0 1.74893359e-05)
    list(6.1e-09 0.816441114 0 1.74863567e-05)
    list(6.10075e-09 0.81642544 0.15 2.74107582e-05)
    list(6.10275e-09 0.81637542 0.55 5.86181729e-05)
    list(6.10475e-09 0.816500025 0.95 7.63014354e-05)
    list(6.10535e-09 0.816555737 1 3.60703786e-05)
    list(6.10725e-09 0.816765611 1 3.35556993e-05)
    list(6.10925e-09 0.816979182 1 3.25252633e-05)
    list(6.11125e-09 0.817189444 1 3.19551718e-05)
    list(6.11325e-09 0.817397807 1 3.16073925e-05)
    list(6.11525e-09 0.817604805 1 3.13799288e-05)
    list(6.11725e-09 0.8178107 1 3.12216824e-05)
    list(6.11925e-09 0.818015656 1 3.11046623e-05)
    list(6.12125e-09 0.818219791 1 3.10127454e-05)
    list(6.12325e-09 0.8184232 1 3.09363772e-05)
    list(6.12525e-09 0.818625957 1 3.08697951e-05)
    list(6.12725e-09 0.818828125 1 3.08094786e-05)
    list(6.12925e-09 0.819029755 1 3.07532541e-05)
    list(6.13015e-09 0.819129244 0.97 -4.44930174e-06)
    list(6.13175e-09 0.819376215 0.65 -1.86341107e-05)
    list(6.13375e-09 0.819506055 0.25 -1.49284097e-05)
    list(6.13505e-09 0.819536931 0 2.21831858e-05)
    list(6.13625e-09 0.819536901 0 2.22133773e-05)
    list(6.13825e-09 0.81953687 0 2.00505267e-05)
    list(6.14025e-09 0.819536849 0 1.9042061e-05)
    list(6.14225e-09 0.819536831 0 1.85398277e-05)
    list(6.14425e-09 0.819536816 0 1.82551344e-05)
    list(6.14625e-09 0.819536801 0 1.80744689e-05)
    list(6.14825e-09 0.819536787 0 1.79499767e-05)
    list(6.15025e-09 0.819536774 0 1.78594541e-05)
    list(6.15225e-09 0.81953676 0 1.77913535e-05)
    list(6.15425e-09 0.819536747 0 1.7738941e-05)
    list(6.15625e-09 0.819536735 0 1.76978993e-05)
    list(6.15825e-09 0.819536722 0 1.76652743e-05)
    list(6.16025e-09 0.819536709 0 1.76389645e-05)
    list(6.16225e-09 0.819536697 0 1.76174449e-05)
    list(6.16425e-09 0.819536684 0 1.75995965e-05)
    list(6.16625e-09 0.819536672 0 1.7584593e-05)
    list(6.16825e-09 0.819536659 0 1.7571821e-05)
    list(6.17025e-09 0.819536647 0 1.75608224e-05)
    list(6.17225e-09 0.819536634 0 1.75512524e-05)
    list(6.17425e-09 0.819536622 0 1.75428493e-05)
    list(6.17625e-09 0.819536609 0 1.75354121e-05)
    list(6.17825e-09 0.819536597 0 1.75287848e-05)
    list(6.18025e-09 0.819536584 0 1.75228447e-05)
    list(6.18225e-09 0.819536571 0 1.7517494e-05)
    list(6.18425e-09 0.819536559 0 1.75126535e-05)
    list(6.18625e-09 0.819536546 0 1.75082584e-05)
    list(6.18825e-09 0.819536534 0 1.75042552e-05)
    list(6.19025e-09 0.819536521 0 1.75005987e-05)
    list(6.19225e-09 0.819536509 0 1.74972507e-05)
    list(6.19425e-09 0.819536496 0 1.74941785e-05)
    list(6.19625e-09 0.819536484 0 1.7491354e-05)
    list(6.19825e-09 0.819536471 0 1.74887525e-05)
    list(6.2e-09 0.81953646 0 1.74857853e-05)
    list(6.20075e-09 0.819520604 0.15 2.74176983e-05)
    list(6.20275e-09 0.819470067 0.55 5.84544881e-05)
    list(6.20475e-09 0.819589448 0.95 7.53988328e-05)
    list(6.20535e-09 0.819642982 1 3.5320035e-05)
    list(6.20725e-09 0.81984817 1 3.30327927e-05)
    list(6.20925e-09 0.820058231 1 3.20757097e-05)
    list(6.21125e-09 0.82026547 1 3.15283574e-05)
    list(6.21325e-09 0.820470983 1 3.11887489e-05)
    list(6.21525e-09 0.820675201 1 3.09651666e-05)
    list(6.21725e-09 0.820878351 1 3.08094185e-05)
    list(6.21925e-09 0.821080582 1 3.06943383e-05)
    list(6.22125e-09 0.821282006 1 3.06040492e-05)
    list(6.22325e-09 0.821482715 1 3.05290849e-05)
    list(6.22525e-09 0.821682781 1 3.04637266e-05)
    list(6.22725e-09 0.821882265 1 3.04044842e-05)
    list(6.22925e-09 0.822081217 1 3.03492082e-05)
    list(6.23015e-09 0.82217956 0.97 -4.79757528e-06)
    list(6.23175e-09 0.82242646 0.65 -1.86994485e-05)
    list(6.23375e-09 0.82255743 0.25 -1.49486183e-05)
    list(6.23505e-09 0.822588618 0 2.21791966e-05)
    list(6.23625e-09 0.822588588 0 2.22020864e-05)
    list(6.23825e-09 0.822588556 0 2.0032227e-05)
    list(6.24025e-09 0.822588535 0 1.90215702e-05)
    list(6.24225e-09 0.822588517 0 1.85203072e-05)
    list(6.24425e-09 0.822588502 0 1.82382307e-05)
    list(6.24625e-09 0.822588487 0 1.8060692e-05)
    list(6.24825e-09 0.822588473 0 1.79391667e-05)
    list(6.25025e-09 0.822588459 0 1.78511604e-05)
    list(6.25225e-09 0.822588446 0 1.77850631e-05)
    list(6.25425e-09 0.822588433 0 1.77341846e-05)
    list(6.25625e-09 0.82258842 0 1.76942887e-05)
    list(6.25825e-09 0.822588407 0 1.76625047e-05)
    list(6.26025e-09 0.822588394 0 1.76368054e-05)
    list(6.26225e-09 0.822588382 0 1.76157255e-05)
    list(6.26425e-09 0.822588369 0 1.75981922e-05)
    list(6.26625e-09 0.822588356 0 1.75834141e-05)
    list(6.26825e-09 0.822588343 0 1.75708034e-05)
    list(6.27025e-09 0.822588331 0 1.75599205e-05)
    list(6.27225e-09 0.822588318 0 1.75504342e-05)
    list(6.27425e-09 0.822588306 0 1.7542092e-05)
    list(6.27625e-09 0.822588293 0 1.75346999e-05)
    list(6.27825e-09 0.82258828 0 1.75281067e-05)
    list(6.28025e-09 0.822588268 0 1.75221929e-05)
    list(6.28225e-09 0.822588255 0 1.75168631e-05)
    list(6.28425e-09 0.822588242 0 1.75120398e-05)
    list(6.28625e-09 0.82258823 0 1.75076594e-05)
    list(6.28825e-09 0.822588217 0 1.7503669e-05)
    list(6.29025e-09 0.822588204 0 1.75000241e-05)
    list(6.29225e-09 0.822588192 0 1.74966869e-05)
    list(6.29425e-09 0.822588179 0 1.74936249e-05)
    list(6.29625e-09 0.822588166 0 1.749081e-05)
    list(6.29825e-09 0.822588154 0 1.74882179e-05)
    list(6.3e-09 0.822588143 0 1.74852619e-05)
    list(6.30075e-09 0.822572105 0.15 2.74245564e-05)
    list(6.30275e-09 0.822521059 0.55 5.8287864e-05)
    list(6.30475e-09 0.822635206 0.95 7.45099886e-05)
    list(6.30535e-09 0.82268659 1 3.45784011e-05)
    list(6.30725e-09 0.822887154 1 3.25156057e-05)
    list(6.30925e-09 0.823093745 1 3.16300138e-05)
    list(6.31125e-09 0.823297988 1 3.11045979e-05)
    list(6.31325e-09 0.823500672 1 3.0772839e-05)
    list(6.31525e-09 0.82370213 1 3.05530056e-05)
    list(6.31725e-09 0.823902552 1 3.03996934e-05)
    list(6.31925e-09 0.824102075 1 3.0286517e-05)
    list(6.32125e-09 0.824300806 1 3.01978309e-05)
    list(6.32325e-09 0.824498831 1 3.01242512e-05)
    list(6.32525e-09 0.824696222 1 3.00601015e-05)
    list(6.32725e-09 0.824893038 1 3.00019209e-05)
    list(6.32925e-09 0.825089327 1 2.99475834e-05)
    list(6.33015e-09 0.825186532 0.97 -5.14378302e-06)
    list(6.33175e-09 0.82543334 0.65 -1.87647297e-05)
    list(6.33375e-09 0.825565429 0.25 -1.49750555e-05)
    list(6.33505e-09 0.825596924 0 2.21748259e-05)
    list(6.33625e-09 0.825596894 0 2.21904234e-05)
    list(6.33825e-09 0.825596862 0 2.00137468e-05)
    list(6.34025e-09 0.82559684 0 1.90011733e-05)
    list(6.34225e-09 0.825596823 0 1.85010879e-05)
    list(6.34425e-09 0.825596807 0 1.82217249e-05)
    list(6.34625e-09 0.825596792 0 1.8047321e-05)
    list(6.34825e-09 0.825596778 0 1.79287223e-05)
    list(6.35025e-09 0.825596764 0 1.78431754e-05)
    list(6.35225e-09 0.82559675 0 1.77790248e-05)
    list(6.35425e-09 0.825596737 0 1.77296318e-05)
    list(6.35625e-09 0.825596724 0 1.76908423e-05)
    list(6.35825e-09 0.825596711 0 1.76598693e-05)
    list(6.36025e-09 0.825596698 0 1.76347579e-05)
    list(6.36225e-09 0.825596686 0 1.7614101e-05)
    list(6.36425e-09 0.825596673 0 1.75968707e-05)
    list(6.36625e-09 0.82559666 0 1.75823092e-05)
    list(6.36825e-09 0.825596647 0 1.75698535e-05)
    list(6.37025e-09 0.825596634 0 1.75590818e-05)
    list(6.37225e-09 0.825596621 0 1.75496758e-05)
    list(6.37425e-09 0.825596609 0 1.75413921e-05)
    list(6.37625e-09 0.825596596 0 1.75340434e-05)
    list(6.37825e-09 0.825596583 0 1.75274827e-05)
    list(6.38025e-09 0.82559657 0 1.75215941e-05)
    list(6.38225e-09 0.825596557 0 1.75162843e-05)
    list(6.38425e-09 0.825596545 0 1.75114774e-05)
    list(6.38625e-09 0.825596532 0 1.75071109e-05)
    list(6.38825e-09 0.825596519 0 1.75031327e-05)
    list(6.39025e-09 0.825596506 0 1.74994988e-05)
    list(6.39225e-09 0.825596493 0 1.74961717e-05)
    list(6.39425e-09 0.825596481 0 1.74931192e-05)
    list(6.39625e-09 0.825596468 0 1.74903135e-05)
    list(6.39825e-09 0.825596455 0 1.74877302e-05)
    list(6.4e-09 0.825596444 0 1.74847846e-05)
    list(6.40075e-09 0.825580228 0.15 2.74313316e-05)
    list(6.40275e-09 0.825528679 0.55 5.81182194e-05)
    list(6.40475e-09 0.825637585 0.95 7.36347174e-05)
    list(6.40535e-09 0.825686847 1 3.38455558e-05)
    list(6.40725e-09 0.825882848 1 3.20041583e-05)
    list(6.40925e-09 0.826086009 1 3.1188221e-05)
    list(6.41125e-09 0.826287284 1 3.06839653e-05)
    list(6.41325e-09 0.826487161 1 3.03597494e-05)
    list(6.41525e-09 0.826685877 1 3.01435388e-05)
    list(6.41725e-09 0.82688359 1 2.99926025e-05)
    list(6.41925e-09 0.827080424 1 2.98812949e-05)
    list(6.42125e-09 0.827276478 1 2.97941873e-05)
    list(6.42325e-09 0.827471837 1 2.97219734e-05)
    list(6.42525e-09 0.827666569 1 2.96590169e-05)
    list(6.42725e-09 0.827860734 1 2.96018856e-05)
    list(6.42925e-09 0.828054378 1 2.95484766e-05)
    list(6.43015e-09 0.828150451 0.97 -5.48789155e-06)
    list(6.43175e-09 0.828397146 0.65 -1.88301112e-05)
    list(6.43375e-09 0.828530343 0.25 -1.50073527e-05)
    list(6.43505e-09 0.828562141 0 2.21700746e-05)
    list(6.43625e-09 0.828562111 0 2.21783999e-05)
    list(6.43825e-09 0.828562079 0 1.99951122e-05)
    list(6.44025e-09 0.828562057 0 1.89808937e-05)
    list(6.44225e-09 0.828562039 0 1.84821816e-05)
    list(6.44425e-09 0.828562023 0 1.82056172e-05)
    list(6.44625e-09 0.828562008 0 1.80343488e-05)
    list(6.44825e-09 0.828561994 0 1.79186334e-05)
    list(6.45025e-09 0.82856198 0 1.78354886e-05)
    list(6.45225e-09 0.828561966 0 1.77732293e-05)
    list(6.45425e-09 0.828561953 0 1.77252743e-05)
    list(6.45625e-09 0.82856194 0 1.76875535e-05)
    list(6.45825e-09 0.828561927 0 1.76573624e-05)
    list(6.46025e-09 0.828561914 0 1.76328171e-05)
    list(6.46225e-09 0.828561901 0 1.76125672e-05)
    list(6.46425e-09 0.828561888 0 1.75956282e-05)
    list(6.46625e-09 0.828561875 0 1.7581275e-05)
    list(6.46825e-09 0.828561862 0 1.75689681e-05)
    list(6.47025e-09 0.828561849 0 1.75583033e-05)
    list(6.47225e-09 0.828561836 0 1.75489743e-05)
    list(6.47425e-09 0.828561823 0 1.75407468e-05)
    list(6.47625e-09 0.82856181 0 1.75334395e-05)
    list(6.47825e-09 0.828561797 0 1.75269101e-05)
    list(6.48025e-09 0.828561784 0 1.75210455e-05)
    list(6.48225e-09 0.828561771 0 1.75157548e-05)
    list(6.48425e-09 0.828561758 0 1.75109635e-05)
    list(6.48625e-09 0.828561745 0 1.75066102e-05)
    list(6.48825e-09 0.828561732 0 1.75026434e-05)
    list(6.49025e-09 0.82856172 0 1.74990199e-05)
    list(6.49225e-09 0.828561707 0 1.74957023e-05)
    list(6.49425e-09 0.828561694 0 1.74926588e-05)
    list(6.49625e-09 0.828561681 0 1.74898616e-05)
    list(6.49825e-09 0.828561668 0 1.74872865e-05)
    list(6.5e-09 0.828561656 0 1.74843507e-05)
    list(6.50075e-09 0.828545263 0.15 2.7438023e-05)
    list(6.50275e-09 0.828493217 0.55 5.7945481e-05)
    list(6.50475e-09 0.82859688 0.95 7.27726988e-05)
    list(6.50535e-09 0.828644046 1 3.31215611e-05)
    list(6.50725e-09 0.828835546 1 3.1498467e-05)
    list(6.50925e-09 0.829035319 1 3.07503769e-05)
    list(6.51125e-09 0.829233652 1 3.02665315e-05)
    list(6.51325e-09 0.829430745 1 2.99495655e-05)
    list(6.51525e-09 0.829626739 1 2.97368574e-05)
    list(6.51725e-09 0.829821762 1 2.95882393e-05)
    list(6.51925e-09 0.830015924 1 2.94787663e-05)
    list(6.52125e-09 0.83020932 1 2.93932127e-05)
    list(6.52325e-09 0.83040203 1 2.93223455e-05)
    list(6.52525e-09 0.830594121 1 2.92605668e-05)
    list(6.52725e-09 0.830785652 1 2.92044722e-05)
    list(6.52925e-09 0.830976668 1 2.91519814e-05)
    list(6.53015e-09 0.831071617 0.97 -5.82987074e-06)
    list(6.53175e-09 0.83131818 0.65 -1.88957274e-05)
    list(6.53375e-09 0.831452474 0.25 -1.50450654e-05)
    list(6.53505e-09 0.83148457 0 2.21649452e-05)
    list(6.53625e-09 0.831484539 0 2.21660292e-05)
    list(6.53825e-09 0.831484507 0 1.99763489e-05)
    list(6.54025e-09 0.831484485 0 1.89607529e-05)
    list(6.54225e-09 0.831484467 0 1.84635981e-05)
    list(6.54425e-09 0.831484451 0 1.81899059e-05)
    list(6.54625e-09 0.831484436 0 1.8021767e-05)
    list(6.54825e-09 0.831484421 0 1.79088893e-05)
    list(6.55025e-09 0.831484407 0 1.78280894e-05)
    list(6.55225e-09 0.831484394 0 1.7767667e-05)
    list(6.55425e-09 0.83148438 0 1.77211039e-05)
    list(6.55625e-09 0.831484367 0 1.76844151e-05)
    list(6.55825e-09 0.831484354 0 1.76549779e-05)
    list(6.56025e-09 0.83148434 0 1.76309777e-05)
    list(6.56225e-09 0.831484327 0 1.76111193e-05)
    list(6.56425e-09 0.831484314 0 1.75944605e-05)
    list(6.56625e-09 0.831484301 0 1.75803073e-05)
    list(6.56825e-09 0.831484288 0 1.75681435e-05)
    list(6.57025e-09 0.831484275 0 1.75575812e-05)
    list(6.57225e-09 0.831484262 0 1.75483261e-05)
    list(6.57425e-09 0.831484249 0 1.75401525e-05)
    list(6.57625e-09 0.831484236 0 1.75328849e-05)
    list(6.57825e-09 0.831484223 0 1.75263854e-05)
    list(6.58025e-09 0.83148421 0 1.75205438e-05)
    list(6.58225e-09 0.831484196 0 1.75152712e-05)
    list(6.58425e-09 0.831484183 0 1.75104947e-05)
    list(6.58625e-09 0.83148417 0 1.75061539e-05)
    list(6.58825e-09 0.831484157 0 1.75021981e-05)
    list(6.59025e-09 0.831484144 0 1.74985842e-05)
    list(6.59225e-09 0.831484131 0 1.74952756e-05)
    list(6.59425e-09 0.831484118 0 1.74922405e-05)
    list(6.59625e-09 0.831484105 0 1.74894512e-05)
    list(6.59825e-09 0.831484092 0 1.74868838e-05)
    list(6.6e-09 0.83148408 0 1.74839572e-05)
    list(6.60075e-09 0.831467512 0.15 2.74446299e-05)
    list(6.60275e-09 0.831414975 0.55 5.77695852e-05)
    list(6.60475e-09 0.831513394 0.95 7.19235971e-05)
    list(6.60535e-09 0.831558493 1 3.24065091e-05)
    list(6.60725e-09 0.831745553 1 3.09985578e-05)
    list(6.60925e-09 0.831941976 1 3.03165298e-05)
    list(6.61125e-09 0.832137397 1 2.98523682e-05)
    list(6.61325e-09 0.832331728 1 2.9542371e-05)
    list(6.61525e-09 0.832525021 1 2.93330501e-05)
    list(6.61725e-09 0.832717373 1 2.91866944e-05)
    list(6.61925e-09 0.832908882 1 2.90790221e-05)
    list(6.62125e-09 0.833099637 1 2.89949982e-05)
    list(6.62325e-09 0.833289717 1 2.89254584e-05)
    list(6.62525e-09 0.833479186 1 2.88648418e-05)
    list(6.62725e-09 0.8336681 1 2.88097711e-05)
    list(6.62925e-09 0.833856506 1 2.8758188e-05)
    list(6.63015e-09 0.833950339 0.97 -6.16969318e-06)
    list(6.63175e-09 0.834196751 0.65 -1.89616918e-05)
    list(6.63375e-09 0.834332129 0.25 -1.50876898e-05)
    list(6.63505e-09 0.834364519 0 2.21594424e-05)
    list(6.63625e-09 0.834364488 0 2.2153326e-05)
    list(6.63825e-09 0.834364455 0 1.99574823e-05)
    list(6.64025e-09 0.834364434 0 1.89407712e-05)
    list(6.64225e-09 0.834364415 0 1.84453451e-05)
    list(6.64425e-09 0.834364399 0 1.81745883e-05)
    list(6.64625e-09 0.834364384 0 1.80095669e-05)
    list(6.64825e-09 0.834364369 0 1.78994791e-05)
    list(6.65025e-09 0.834364355 0 1.7820967e-05)
    list(6.65225e-09 0.834364342 0 1.7762328e-05)
    list(6.65425e-09 0.834364328 0 1.77171121e-05)
    list(6.65625e-09 0.834364314 0 1.76814197e-05)
    list(6.65825e-09 0.834364301 0 1.76527094e-05)
    list(6.66025e-09 0.834364288 0 1.76292341e-05)
    list(6.66225e-09 0.834364275 0 1.76097524e-05)
    list(6.66425e-09 0.834364261 0 1.7593363e-05)
    list(6.66625e-09 0.834364248 0 1.75794021e-05)
    list(6.66825e-09 0.834364235 0 1.75673756e-05)
    list(6.67025e-09 0.834364222 0 1.75569117e-05)
    list(6.67225e-09 0.834364208 0 1.75477275e-05)
    list(6.67425e-09 0.834364195 0 1.75396055e-05)
    list(6.67625e-09 0.834364182 0 1.7532376e-05)
    list(6.67825e-09 0.834364169 0 1.75259049e-05)
    list(6.68025e-09 0.834364156 0 1.75200853e-05)
    list(6.68225e-09 0.834364142 0 1.75148299e-05)
    list(6.68425e-09 0.834364129 0 1.75100675e-05)
    list(6.68625e-09 0.834364116 0 1.75057385e-05)
    list(6.68825e-09 0.834364103 0 1.75017929e-05)
    list(6.69025e-09 0.834364089 0 1.74981883e-05)
    list(6.69225e-09 0.834364076 0 1.7494888e-05)
    list(6.69425e-09 0.834364063 0 1.74918608e-05)
    list(6.69625e-09 0.83436405 0 1.7489079e-05)
    list(6.69825e-09 0.834364036 0 1.74865188e-05)
    list(6.7e-09 0.834364025 0 1.74836006e-05)
    list(6.70075e-09 0.834347283 0.15 2.74511517e-05)
    list(6.70275e-09 0.83429426 0.55 5.75904786e-05)
    list(6.70475e-09 0.834387437 0.95 7.10869208e-05)
    list(6.70535e-09 0.834430498 1 3.17004456e-05)
    list(6.70725e-09 0.83461318 1 3.05044443e-05)
    list(6.70925e-09 0.834806293 1 2.9886725e-05)
    list(6.71125e-09 0.83499883 1 2.94415453e-05)
    list(6.71325e-09 0.835190421 1 2.91382479e-05)
    list(6.71525e-09 0.835381035 1 2.89322037e-05)
    list(6.71725e-09 0.835570735 1 2.87880561e-05)
    list(6.71925e-09 0.835759611 1 2.86821508e-05)
    list(6.72125e-09 0.835947745 1 2.85996319e-05)
    list(6.72325e-09 0.836135212 1 2.85313999e-05)
    list(6.72525e-09 0.836322077 1 2.84719295e-05)
    list(6.72725e-09 0.836508394 1 2.84178693e-05)
    list(6.72925e-09 0.836694208 1 2.83671831e-05)
    list(6.73015e-09 0.836786932 0.97 -6.50733338e-06)
    list(6.73175e-09 0.837033175 0.65 -1.90281008e-05)
    list(6.73375e-09 0.837169626 0.25 -1.51346779e-05)
    list(6.73505e-09 0.837202306 0 2.21535724e-05)
    list(6.73625e-09 0.837202274 0 2.21403062e-05)
    list(6.73825e-09 0.837202241 0 1.99385371e-05)
    list(6.74025e-09 0.837202219 0 1.89209668e-05)
    list(6.74225e-09 0.837202201 0 1.84274288e-05)
    list(6.74425e-09 0.837202185 0 1.81596603e-05)
    list(6.74625e-09 0.837202169 0 1.79977388e-05)
    list(6.74825e-09 0.837202155 0 1.78903915e-05)
    list(6.75025e-09 0.837202141 0 1.78141102e-05)
    list(6.75225e-09 0.837202127 0 1.77572025e-05)
    list(6.75425e-09 0.837202113 0 1.77132902e-05)
    list(6.75625e-09 0.837202099 0 1.76785601e-05)
    list(6.75825e-09 0.837202086 0 1.76505503e-05)
    list(6.76025e-09 0.837202072 0 1.76275805e-05)
    list(6.76225e-09 0.837202059 0 1.76084612e-05)
    list(6.76425e-09 0.837202046 0 1.75923307e-05)
    list(6.76625e-09 0.837202032 0 1.75785545e-05)
    list(6.76825e-09 0.837202019 0 1.75666599e-05)
    list(6.77025e-09 0.837202005 0 1.75562904e-05)
    list(6.77225e-09 0.837201992 0 1.75471743e-05)
    list(6.77425e-09 0.837201979 0 1.75391017e-05)
    list(6.77625e-09 0.837201965 0 1.75319085e-05)
    list(6.77825e-09 0.837201952 0 1.75254647e-05)
    list(6.78025e-09 0.837201939 0 1.75196659e-05)
    list(6.78225e-09 0.837201925 0 1.7514427e-05)
    list(6.78425e-09 0.837201912 0 1.75096779e-05)
    list(6.78625e-09 0.837201899 0 1.75053601e-05)
    list(6.78825e-09 0.837201885 0 1.75014242e-05)
    list(6.79025e-09 0.837201872 0 1.74978282e-05)
    list(6.79225e-09 0.837201858 0 1.74945358e-05)
    list(6.79425e-09 0.837201845 0 1.74915159e-05)
    list(6.79625e-09 0.837201832 0 1.74887411e-05)
    list(6.79825e-09 0.837201818 0 1.74861876e-05)
    list(6.8e-09 0.837201807 0 1.74832773e-05)
    list(6.80075e-09 0.837184893 0.15 2.74575881e-05)
    list(6.80275e-09 0.837131389 0.55 5.74081185e-05)
    list(6.80475e-09 0.83721933 0.95 7.02621587e-05)
    list(6.80535e-09 0.837260379 1 3.10033363e-05)
    list(6.80725e-09 0.837438744 1 3.00160761e-05)
    list(6.80925e-09 0.837628588 1 2.9460994e-05)
    list(6.81125e-09 0.837818268 1 2.90341187e-05)
    list(6.81325e-09 0.838007144 1 2.87372644e-05)
    list(6.81525e-09 0.838195098 1 2.85343918e-05)
    list(6.81725e-09 0.838382169 1 2.83924002e-05)
    list(6.81925e-09 0.83856843 1 2.82882239e-05)
    list(6.82125e-09 0.838753962 1 2.82071873e-05)
    list(6.82325e-09 0.838938837 1 2.81402449e-05)
    list(6.82525e-09 0.839123118 1 2.80819055e-05)
    list(6.82725e-09 0.839306856 1 2.80288436e-05)
    list(6.82925e-09 0.839490097 1 2.79790439e-05)
    list(6.83015e-09 0.83958172 0.97 -6.84276671e-06)
    list(6.83175e-09 0.839827778 0.65 -1.90950316e-05)
    list(6.83375e-09 0.839965287 0.25 -1.51854509e-05)
    list(6.83505e-09 0.839998253 0 2.21473431e-05)
    list(6.83625e-09 0.839998221 0 2.21269867e-05)
    list(6.83825e-09 0.839998188 0 1.99195373e-05)
    list(6.84025e-09 0.839998166 0 1.89013565e-05)
    list(6.84225e-09 0.839998147 0 1.84098538e-05)
    list(6.84425e-09 0.839998131 0 1.81451168e-05)
    list(6.84625e-09 0.839998115 0 1.79862727e-05)
    list(6.84825e-09 0.839998101 0 1.78816149e-05)
    list(6.85025e-09 0.839998086 0 1.78075082e-05)
    list(6.85225e-09 0.839998072 0 1.77522806e-05)
    list(6.85425e-09 0.839998058 0 1.77096296e-05)
    list(6.85625e-09 0.839998045 0 1.76758285e-05)
    list(6.85825e-09 0.839998031 0 1.76484941e-05)
    list(6.86025e-09 0.839998018 0 1.7626011e-05)
    list(6.86225e-09 0.839998004 0 1.76072403e-05)
    list(6.86425e-09 0.83999799 0 1.75913587e-05)
    list(6.86625e-09 0.839997977 0 1.75777599e-05)
    list(6.86825e-09 0.839997963 0 1.75659918e-05)
    list(6.87025e-09 0.83999795 0 1.75557129e-05)
    list(6.87225e-09 0.839997936 0 1.7546662e-05)
    list(6.87425e-09 0.839997923 0 1.75386367e-05)
    list(6.87625e-09 0.839997909 0 1.75314783e-05)
    list(6.87825e-09 0.839997896 0 1.75250606e-05)
    list(6.88025e-09 0.839997882 0 1.75192816e-05)
    list(6.88225e-09 0.839997869 0 1.75140584e-05)
    list(6.88425e-09 0.839997855 0 1.75093219e-05)
    list(6.88625e-09 0.839997842 0 1.75050147e-05)
    list(6.88825e-09 0.839997828 0 1.75010879e-05)
    list(6.89025e-09 0.839997815 0 1.74975e-05)
    list(6.89225e-09 0.839997801 0 1.7494215e-05)
    list(6.89425e-09 0.839997788 0 1.7491202e-05)
    list(6.89625e-09 0.839997774 0 1.74884337e-05)
    list(6.89825e-09 0.839997761 0 1.74858865e-05)
    list(6.9e-09 0.839997749 0 1.74829835e-05)
    list(6.90075e-09 0.839980666 0.15 2.74639386e-05)
    list(6.90275e-09 0.839926685 0.55 5.72224746e-05)
    list(6.90475e-09 0.840009398 0.95 6.9448772e-05)
    list(6.90535e-09 0.840048464 1 3.03153937e-05)
    list(6.90725e-09 0.840222572 1 2.95335891e-05)
    list(6.90925e-09 0.840409187 1 2.90393742e-05)
    list(6.91125e-09 0.840596039 1 2.86301596e-05)
    list(6.91325e-09 0.840782222 1 2.83395065e-05)
    list(6.91525e-09 0.84096754 1 2.81397058e-05)
    list(6.91725e-09 0.841152 1 2.79998194e-05)
    list(6.91925e-09 0.841335668 1 2.78973506e-05)
    list(6.92125e-09 0.841518619 1 2.78177688e-05)
    list(6.92325e-09 0.841700921 1 2.77520937e-05)
    list(6.92525e-09 0.841882636 1 2.7694867e-05)
    list(6.92725e-09 0.842063815 1 2.76427879e-05)
    list(6.92925e-09 0.842244503 1 2.75938622e-05)
    list(6.93015e-09 0.842335033 0.97 -7.1759699e-06)
    list(6.93175e-09 0.842580889 0.65 -1.91625464e-05)
    list(6.93375e-09 0.842719445 0.25 -1.52394133e-05)
    list(6.93505e-09 0.842752692 0 2.21407637e-05)
    list(6.93625e-09 0.84275266 0 2.21133853e-05)
    list(6.93825e-09 0.842752626 0 1.99005062e-05)
    list(6.94025e-09 0.842752604 0 1.88819554e-05)
    list(6.94225e-09 0.842752585 0 1.83926232e-05)
    list(6.94425e-09 0.842752569 0 1.81309518e-05)
    list(6.94625e-09 0.842752553 0 1.79751582e-05)
    list(6.94825e-09 0.842752538 0 1.78731378e-05)
    list(6.95025e-09 0.842752524 0 1.780115e-05)
    list(6.95225e-09 0.84275251 0 1.77475525e-05)
    list(6.95425e-09 0.842752496 0 1.77061217e-05)
    list(6.95625e-09 0.842752482 0 1.76732175e-05)
    list(6.95825e-09 0.842752468 0 1.76465342e-05)
    list(6.96025e-09 0.842752455 0 1.76245196e-05)
    list(6.96225e-09 0.842752441 0 1.76060843e-05)
    list(6.96425e-09 0.842752427 0 1.75904418e-05)
    list(6.96625e-09 0.842752413 0 1.75770134e-05)
    list(6.96825e-09 0.8427524 0 1.75653668e-05)
    list(6.97025e-09 0.842752386 0 1.75551748e-05)
    list(6.97225e-09 0.842752373 0 1.75461862e-05)
    list(6.97425e-09 0.842752359 0 1.75382062e-05)
    list(6.97625e-09 0.842752345 0 1.75310811e-05)
    list(6.97825e-09 0.842752332 0 1.75246881e-05)
    list(6.98025e-09 0.842752318 0 1.75189281e-05)
    list(6.98225e-09 0.842752304 0 1.75137197e-05)
    list(6.98425e-09 0.842752291 0 1.75089952e-05)
    list(6.98625e-09 0.842752277 0 1.7504698e-05)
    list(6.98825e-09 0.842752263 0 1.75007798e-05)
    list(6.99025e-09 0.84275225 0 1.74971995e-05)
    list(6.99225e-09 0.842752236 0 1.74939215e-05)
    list(6.99425e-09 0.842752222 0 1.7490915e-05)
    list(6.99625e-09 0.842752209 0 1.74881529e-05)
    list(6.99825e-09 0.842752195 0 1.74856115e-05)
    list(7e-09 0.842752183 0 1.74827154e-05)
    list(7.00075e-09 0.842734933 0.15 2.74702028e-05)
    list(7.00275e-09 0.842680479 0.55 5.70335284e-05)
    list(7.00475e-09 0.842757973 0.95 6.86462151e-05)
    list(7.00535e-09 0.842795082 1 2.96362719e-05)
    list(7.00725e-09 0.842964995 1 2.90567723e-05)
    list(7.00925e-09 0.84314842 1 2.86218416e-05)
    list(7.01125e-09 0.843332472 1 2.82296649e-05)
    list(7.01325e-09 0.843515988 1 2.79449833e-05)
    list(7.01525e-09 0.84369869 1 2.7748163e-05)
    list(7.01725e-09 0.843880562 1 2.76103378e-05)
    list(7.01925e-09 0.844061657 1 2.75095437e-05)
    list(7.02125e-09 0.844242046 1 2.74313982e-05)
    list(7.02325e-09 0.844421796 1 2.73669758e-05)
    list(7.02525e-09 0.844600966 1 2.73108497e-05)
    list(7.02725e-09 0.844779606 1 2.72597437e-05)
    list(7.02925e-09 0.84495776 1 2.72116839e-05)
    list(7.03015e-09 0.845047205 0.97 -7.50691912e-06)
    list(7.03175e-09 0.845292844 0.65 -1.92306928e-05)
    list(7.03375e-09 0.845432435 0.25 -1.52959607e-05)
    list(7.03505e-09 0.845465957 0 2.21338459e-05)
    list(7.03625e-09 0.845465925 0 2.20995212e-05)
    list(7.03825e-09 0.845465891 0 1.98814667e-05)
    list(7.04025e-09 0.845465869 0 1.88627772e-05)
    list(7.04225e-09 0.84546585 0 1.83757387e-05)
    list(7.04425e-09 0.845465834 0 1.81171587e-05)
    list(7.04625e-09 0.845465818 0 1.79643846e-05)
    list(7.04825e-09 0.845465803 0 1.78649488e-05)
    list(7.05025e-09 0.845465788 0 1.77950246e-05)
    list(7.05225e-09 0.845465774 0 1.77430084e-05)
    list(7.05425e-09 0.84546576 0 1.7702758e-05)
    list(7.05625e-09 0.845465746 0 1.76707197e-05)
    list(7.05825e-09 0.845465732 0 1.76446639e-05)
    list(7.06025e-09 0.845465718 0 1.76231004e-05)
    list(7.06225e-09 0.845465704 0 1.76049875e-05)
    list(7.06425e-09 0.84546569 0 1.75895749e-05)
    list(7.06625e-09 0.845465677 0 1.75763101e-05)
    list(7.06825e-09 0.845465663 0 1.756478e-05)
    list(7.07025e-09 0.845465649 0 1.75546712e-05)
    list(7.07225e-09 0.845465635 0 1.75457425e-05)
    list(7.07425e-09 0.845465622 0 1.75378058e-05)
    list(7.07625e-09 0.845465608 0 1.75307124e-05)
    list(7.07825e-09 0.845465594 0 1.75243431e-05)
    list(7.08025e-09 0.84546558 0 1.75186011e-05)
    list(7.08225e-09 0.845465566 0 1.75134068e-05)
    list(7.08425e-09 0.845465553 0 1.75086937e-05)
    list(7.08625e-09 0.845465539 0 1.75044059e-05)
    list(7.08825e-09 0.845465525 0 1.75004958e-05)
    list(7.09025e-09 0.845465511 0 1.74969228e-05)
    list(7.09225e-09 0.845465497 0 1.74936513e-05)
    list(7.09425e-09 0.845465484 0 1.74906509e-05)
    list(7.09625e-09 0.84546547 0 1.74878945e-05)
    list(7.09825e-09 0.845465456 0 1.74853586e-05)
    list(7.1e-09 0.845465444 1.65436123e-13 1.7482469e-05)
    list(7.10075e-09 0.845448028 0.15 2.74763806e-05)
    list(7.10275e-09 0.845393105 0.55 5.68412737e-05)
    list(7.10475e-09 0.845465394 0.95 6.78539556e-05)
    list(7.10535e-09 0.845500616 1 2.87402536e-05)
    list(7.10725e-09 0.845666369 1 2.83716794e-05)
    list(7.10925e-09 0.845846637 1 2.8002332e-05)
    list(7.11125e-09 0.846027916 1 2.76328808e-05)
    list(7.11325e-09 0.846208788 1 2.73592758e-05)
    list(7.11525e-09 0.846388898 1 2.71699527e-05)
    list(7.11725e-09 0.846568202 1 2.70381548e-05)
    list(7.11925e-09 0.846746746 1 2.69425078e-05)
    list(7.12125e-09 0.846924595 1 2.68688363e-05)
    list(7.12325e-09 0.847101813 1 2.68083239e-05)
    list(7.12525e-09 0.847278458 1 2.67556243e-05)
    list(7.12725e-09 0.847454579 1 2.67075286e-05)
    list(7.12925e-09 0.84763022 1 2.66621204e-05)
    list(7.13015e-09 0.847718589 0.97 -7.83484155e-06)
    list(7.13175e-09 0.847963995 0.65 -1.92988773e-05)
    list(7.13375e-09 0.848104607 0.25 -1.53539457e-05)
    list(7.13505e-09 0.848138401 0 2.21265623e-05)
    list(7.13625e-09 0.848138369 0 2.20853852e-05)
    list(7.13825e-09 0.848138335 0 1.98624166e-05)
    list(7.14025e-09 0.848138312 0 1.88438138e-05)
    list(7.14225e-09 0.848138294 0 1.83591833e-05)
    list(7.14425e-09 0.848138277 0 1.81037149e-05)
    list(7.14625e-09 0.848138261 0 1.79539279e-05)
    list(7.14825e-09 0.848138246 0 1.78570249e-05)
    list(7.15025e-09 0.848138231 0 1.77891114e-05)
    list(7.15225e-09 0.848138217 0 1.77386303e-05)
    list(7.15425e-09 0.848138202 0 1.76995228e-05)
    list(7.15625e-09 0.848138188 0 1.76683213e-05)
    list(7.15825e-09 0.848138174 0 1.76428712e-05)
    list(7.16025e-09 0.84813816 0 1.76217428e-05)
    list(7.16225e-09 0.848138146 0 1.76039408e-05)
    list(7.16425e-09 0.848138132 0 1.75887495e-05)
    list(7.16625e-09 0.848138118 0 1.75756423e-05)
    list(7.16825e-09 0.848138104 0 1.75642245e-05)
    list(7.17025e-09 0.848138091 0 1.75541959e-05)
    list(7.17225e-09 0.848138077 0 1.75453247e-05)
    list(7.17425e-09 0.848138063 0 1.75374297e-05)
    list(7.17625e-09 0.848138049 0 1.75303669e-05)
    list(7.17825e-09 0.848138035 0 1.75240204e-05)
    list(7.18025e-09 0.848138021 0 1.75182958e-05)
    list(7.18225e-09 0.848138007 0 1.7513115e-05)
    list(7.18425e-09 0.848137993 0 1.75084128e-05)
    list(7.18625e-09 0.848137979 0 1.75041341e-05)
    list(7.18825e-09 0.848137965 0 1.75002319e-05)
    list(7.19025e-09 0.848137951 0 1.74966657e-05)
    list(7.19225e-09 0.848137937 0 1.74934005e-05)
    list(7.19425e-09 0.848137923 0 1.74904059e-05)
    list(7.19625e-09 0.848137909 0 1.7487655e-05)
    list(7.19825e-09 0.848137895 0 1.74851244e-05)
    list(7.2e-09 0.848137883 0 1.7482241e-05)
    list(7.20075e-09 0.848120304 0.15 2.74824719e-05)
    list(7.20275e-09 0.848064915 0.55 5.6645716e-05)
    list(7.20475e-09 0.848132013 0.95 6.70714877e-05)
    list(7.20535e-09 0.848165648 1 2.79972918e-05)
    list(7.20725e-09 0.848327042 1 2.8380768e-05)
    list(7.20925e-09 0.848504178 1 2.80484409e-05)
    list(7.21125e-09 0.84868271 1 2.76763647e-05)
    list(7.21325e-09 0.848860962 1 2.73916826e-05)
    list(7.21525e-09 0.849038502 1 2.71905333e-05)
    list(7.21725e-09 0.849215262 1 2.70479052e-05)
    list(7.21925e-09 0.849391276 1 2.69426935e-05)
    list(7.22125e-09 0.849566606 1 2.68606533e-05)
    list(7.22325e-09 0.849741313 1 2.6792837e-05)
    list(7.22525e-09 0.849915455 1 2.67337691e-05)
    list(7.22725e-09 0.850089079 1 2.6680125e-05)
    list(7.22925e-09 0.850262228 1 2.66298867e-05)
    list(7.23015e-09 0.85034953 0.97 -8.16418032e-06)
    list(7.23175e-09 0.850594688 0.65 -1.93702757e-05)
    list(7.23375e-09 0.850736307 0.25 -1.5415562e-05)
    list(7.23505e-09 0.85077037 0 2.2119112e-05)
    list(7.23625e-09 0.850770337 0 2.20711316e-05)
    list(7.23825e-09 0.850770303 0 1.98434935e-05)
    list(7.24025e-09 0.85077028 0 1.88251778e-05)
    list(7.24225e-09 0.850770261 0 1.83430454e-05)
    list(7.24425e-09 0.850770244 0 1.80906899e-05)
    list(7.24625e-09 0.850770228 0 1.79438449e-05)
    list(7.24825e-09 0.850770213 0 1.78494139e-05)
    list(7.25025e-09 0.850770198 0 1.77834515e-05)
    list(7.25225e-09 0.850770184 0 1.77344535e-05)
    list(7.25425e-09 0.850770169 0 1.76964467e-05)
    list(7.25625e-09 0.850770155 0 1.76660488e-05)
    list(7.25825e-09 0.850770141 0 1.76411789e-05)
    list(7.26025e-09 0.850770127 0 1.7620466e-05)
    list(7.26225e-09 0.850770113 0 1.760296e-05)
    list(7.26425e-09 0.850770099 0 1.7587979e-05)
    list(7.26625e-09 0.850770084 0 1.75750209e-05)
    list(7.26825e-09 0.85077007 0 1.75637088e-05)
    list(7.27025e-09 0.850770056 0 1.75537552e-05)
    list(7.27225e-09 0.850770042 0 1.75449377e-05)
    list(7.27425e-09 0.850770028 0 1.75370812e-05)
    list(7.27625e-09 0.850770014 0 1.75300464e-05)
    list(7.27825e-09 0.85077 0 1.75237207e-05)
    list(7.28025e-09 0.850769986 0 1.75180117e-05)
    list(7.28225e-09 0.850769972 0 1.75128431e-05)
    list(7.28425e-09 0.850769958 0 1.75081506e-05)
    list(7.28625e-09 0.850769944 0 1.75038799e-05)
    list(7.28825e-09 0.85076993 0 1.74999846e-05)
    list(7.29025e-09 0.850769916 0 1.74964245e-05)
    list(7.29225e-09 0.850769902 0 1.74931649e-05)
    list(7.29425e-09 0.850769887 0 1.74901755e-05)
    list(7.29625e-09 0.850769873 0 1.74874296e-05)
    list(7.29825e-09 0.850769859 0 1.74849037e-05)
    list(7.3e-09 0.850769847 0 1.74820259e-05)
    list(7.30075e-09 0.850752107 0.15 2.74884765e-05)
    list(7.30275e-09 0.850696254 0.55 5.64468735e-05)
    list(7.30475e-09 0.85075818 0.95 6.6298355e-05)
    list(7.30535e-09 0.850790264 1 2.7325164e-05)
    list(7.30725e-09 0.850947367 1 2.78952417e-05)
    list(7.30925e-09 0.8511214 1 2.76210543e-05)
    list(7.31125e-09 0.851297211 1 2.72646001e-05)
    list(7.31325e-09 0.851472867 1 2.69847973e-05)
    list(7.31525e-09 0.85164786 1 2.67857751e-05)
    list(7.31725e-09 0.851822097 1 2.66445068e-05)
    list(7.31925e-09 0.851995603 1 2.65403756e-05)
    list(7.32125e-09 0.852168435 1 2.64592621e-05)
    list(7.32325e-09 0.852340654 1 2.639226e-05)
    list(7.32525e-09 0.852512313 1 2.63339158e-05)
    list(7.32725e-09 0.852683461 1 2.62809211e-05)
    list(7.32925e-09 0.852854139 1 2.62312716e-05)
    list(7.33015e-09 0.852940382 0.97 -8.48834536e-06)
    list(7.33175e-09 0.85318528 0.65 -1.94405525e-05)
    list(7.33375e-09 0.853327893 0.25 -1.54764107e-05)
    list(7.33505e-09 0.853362219 0 2.21112542e-05)
    list(7.33625e-09 0.853362186 0 2.20565954e-05)
    list(7.33825e-09 0.853362152 0 1.98245557e-05)
    list(7.34025e-09 0.853362129 0 1.88067373e-05)
    list(7.34225e-09 0.85336211 0 1.83272001e-05)
    list(7.34425e-09 0.853362093 0 1.80779679e-05)
    list(7.34625e-09 0.853362077 0 1.79340305e-05)
    list(7.34825e-09 0.853362061 0 1.78420226e-05)
    list(7.35025e-09 0.853362046 0 1.7777963e-05)
    list(7.35225e-09 0.853362032 0 1.7730407e-05)
    list(7.35425e-09 0.853362017 0 1.7693468e-05)
    list(7.35625e-09 0.853362003 0 1.76638487e-05)
    list(7.35825e-09 0.853361988 0 1.76395404e-05)
    list(7.36025e-09 0.853361974 0 1.76192297e-05)
    list(7.36225e-09 0.85336196 0 1.76020104e-05)
    list(7.36425e-09 0.853361946 0 1.7587233e-05)
    list(7.36625e-09 0.853361931 0 1.75744194e-05)
    list(7.36825e-09 0.853361917 0 1.756321e-05)
    list(7.37025e-09 0.853361903 0 1.75533296e-05)
    list(7.37225e-09 0.853361889 0 1.75445643e-05)
    list(7.37425e-09 0.853361874 0 1.75367456e-05)
    list(7.37625e-09 0.85336186 0 1.75297383e-05)
    list(7.37825e-09 0.853361846 0 1.7523433e-05)
    list(7.38025e-09 0.853361832 0 1.75177395e-05)
    list(7.38225e-09 0.853361818 0 1.75125829e-05)
    list(7.38425e-09 0.853361803 0 1.75079001e-05)
    list(7.38625e-09 0.853361789 0 1.75036375e-05)
    list(7.38825e-09 0.853361775 0 1.7499749e-05)
    list(7.39025e-09 0.853361761 0 1.74961951e-05)
    list(7.39225e-09 0.853361747 0 1.74929411e-05)
    list(7.39425e-09 0.853361732 0 1.74899568e-05)
    list(7.39625e-09 0.853361718 0 1.74872157e-05)
    list(7.39825e-09 0.853361704 0 1.74846945e-05)
    list(7.4e-09 0.853361691 0 1.74818222e-05)
    list(7.40075e-09 0.853343792 0.15 2.74943948e-05)
    list(7.40275e-09 0.853287478 0.55 5.62447743e-05)
    list(7.40475e-09 0.853344252 0.95 6.55349076e-05)
    list(7.40535e-09 0.85337481 1 2.66633951e-05)
    list(7.40725e-09 0.853527695 1 2.71306724e-05)
    list(7.40925e-09 0.85369866 1 2.69259502e-05)
    list(7.41125e-09 0.853871777 1 2.65952535e-05)
    list(7.41325e-09 0.854044861 1 2.63293183e-05)
    list(7.41525e-09 0.85421733 1 2.61403207e-05)
    list(7.41725e-09 0.854389067 1 2.60073213e-05)
    list(7.41925e-09 0.854560087 1 2.59103051e-05)
    list(7.42125e-09 0.854730444 1 2.58353866e-05)
    list(7.42325e-09 0.854900196 1 2.57737983e-05)
    list(7.42525e-09 0.855069395 1 2.57201943e-05)
    list(7.42725e-09 0.855238088 1 2.5671358e-05)
    list(7.42925e-09 0.855406316 1 2.56253639e-05)
    list(7.43015e-09 0.855491509 0.97 -8.80889151e-06)
    list(7.43175e-09 0.855736133 0.65 -1.95104771e-05)
    list(7.43375e-09 0.855879727 0.25 -1.5536633e-05)
    list(7.43505e-09 0.855914312 0 2.21030475e-05)
    list(7.43625e-09 0.855914279 0 2.20418287e-05)
    list(7.43825e-09 0.855914244 0 1.98056502e-05)
    list(7.44025e-09 0.855914221 0 1.87885253e-05)
    list(7.44225e-09 0.855914202 0 1.83116664e-05)
    list(7.44425e-09 0.855914185 0 1.8065559e-05)
    list(7.44625e-09 0.855914168 0 1.79244904e-05)
    list(7.44825e-09 0.855914153 0 1.78348547e-05)
    list(7.45025e-09 0.855914138 0 1.77726489e-05)
    list(7.45225e-09 0.855914123 0 1.7726493e-05)
    list(7.45425e-09 0.855914108 0 1.76905887e-05)
    list(7.45625e-09 0.855914094 0 1.76617226e-05)
    list(7.45825e-09 0.855914079 0 1.76379571e-05)
    list(7.46025e-09 0.855914065 0 1.76180349e-05)
    list(7.46225e-09 0.855914051 0 1.76010923e-05)
    list(7.46425e-09 0.855914036 0 1.75865116e-05)
    list(7.46625e-09 0.855914022 0 1.75738376e-05)
    list(7.46825e-09 0.855914007 0 1.75627273e-05)
    list(7.47025e-09 0.855913993 0 1.75529176e-05)
    list(7.47225e-09 0.855913979 0 1.75442029e-05)
    list(7.47425e-09 0.855913964 0 1.75364208e-05)
    list(7.47625e-09 0.85591395 0 1.75294403e-05)
    list(7.47825e-09 0.855913936 0 1.75231548e-05)
    list(7.48025e-09 0.855913921 0 1.75174764e-05)
    list(7.48225e-09 0.855913907 0 1.75123316e-05)
    list(7.48425e-09 0.855913893 0 1.75076583e-05)
    list(7.48625e-09 0.855913878 0 1.75034035e-05)
    list(7.48825e-09 0.855913864 0 1.74995218e-05)
    list(7.49025e-09 0.855913849 0 1.74959738e-05)
    list(7.49225e-09 0.855913835 0 1.74927253e-05)
    list(7.49425e-09 0.855913821 0 1.74897461e-05)
    list(7.49625e-09 0.855913806 0 1.74870099e-05)
    list(7.49825e-09 0.855913792 0 1.74844933e-05)
    list(7.5e-09 0.855913779 0 1.74816264e-05)
    list(7.50075e-09 0.855895723 0.15 2.75002266e-05)
    list(7.50275e-09 0.85583895 0.55 5.60394583e-05)
    list(7.50475e-09 0.855890586 0.95 6.47715154e-05)
    list(7.50535e-09 0.855919638 1 2.60111512e-05)
    list(7.50725e-09 0.856068374 1 2.6718601e-05)
    list(7.50925e-09 0.856236297 1 2.65684943e-05)
    list(7.51125e-09 0.856406746 1 2.62503394e-05)
    list(7.51325e-09 0.856577284 1 2.59867412e-05)
    list(7.51525e-09 0.856747253 1 2.5797726e-05)
    list(7.51725e-09 0.856916513 1 2.56642426e-05)
    list(7.51925e-09 0.85708507 1 2.55667078e-05)
    list(7.52125e-09 0.857252975 1 2.54913241e-05)
    list(7.52325e-09 0.857420281 1 2.5429337e-05)
    list(7.52525e-09 0.857587042 1 2.5375399e-05)
    list(7.52725e-09 0.857753302 1 2.53262898e-05)
    list(7.52925e-09 0.857919103 1 2.52800798e-05)
    list(7.53015e-09 0.858003256 0.97 -9.12865488e-06)
    list(7.53175e-09 0.858247594 0.65 -1.95824227e-05)
    list(7.53375e-09 0.858392154 0.25 -1.55978064e-05)
    list(7.53505e-09 0.858426994 0 2.20946549e-05)
    list(7.53625e-09 0.858426961 0 2.20269583e-05)
    list(7.53825e-09 0.858426926 0 1.97868857e-05)
    list(7.54025e-09 0.858426902 0 1.87706271e-05)
    list(7.54225e-09 0.858426883 0 1.82965096e-05)
    list(7.54425e-09 0.858426866 0 1.8053514e-05)
    list(7.54625e-09 0.858426849 0 1.79152659e-05)
    list(7.54825e-09 0.858426834 0 1.78279449e-05)
    list(7.55025e-09 0.858426819 0 1.77675388e-05)
    list(7.55225e-09 0.858426804 0 1.77227375e-05)
    list(7.55425e-09 0.858426789 0 1.76878311e-05)
    list(7.55625e-09 0.858426774 0 1.76596899e-05)
    list(7.55825e-09 0.85842676 0 1.76364456e-05)
    list(7.56025e-09 0.858426745 0 1.76168955e-05)
    list(7.56225e-09 0.85842673 0 1.76002175e-05)
    list(7.56425e-09 0.858426716 0 1.75858243e-05)
    list(7.56625e-09 0.858426701 0 1.75732831e-05)
    list(7.56825e-09 0.858426687 0 1.75622669e-05)
    list(7.57025e-09 0.858426672 0 1.75525239e-05)
    list(7.57225e-09 0.858426658 0 1.75438569e-05)
    list(7.57425e-09 0.858426643 0 1.7536109e-05)
    list(7.57625e-09 0.858426629 0 1.75291533e-05)
    list(7.57825e-09 0.858426614 0 1.75228863e-05)
    list(7.58025e-09 0.8584266 0 1.75172218e-05)
    list(7.58225e-09 0.858426585 0 1.75120878e-05)
    list(7.58425e-09 0.858426571 0 1.75074232e-05)
    list(7.58625e-09 0.858426556 0 1.75031756e-05)
    list(7.58825e-09 0.858426542 0 1.74993001e-05)
    list(7.59025e-09 0.858426527 0 1.74957577e-05)
    list(7.59225e-09 0.858426513 0 1.74925142e-05)
    list(7.59425e-09 0.858426498 0 1.74895397e-05)
    list(7.59625e-09 0.858426484 0 1.7486808e-05)
    list(7.59825e-09 0.858426469 0 1.74842957e-05)
    list(7.6e-09 0.858426457 0 1.74814339e-05)
    list(7.60075e-09 0.858408246 0.15 2.75059721e-05)
    list(7.60275e-09 0.858351015 0.55 5.58309764e-05)
    list(7.60475e-09 0.858397545 0.95 6.40240236e-05)
    list(7.60535e-09 0.858425118 1 2.53699065e-05)
    list(7.60725e-09 0.858569782 1 2.65235796e-05)
    list(7.60925e-09 0.858734697 1 2.64183838e-05)
    list(7.61125e-09 0.858902508 1 2.61044645e-05)
    list(7.61325e-09 0.859070524 1 2.58360978e-05)
    list(7.61525e-09 0.859238017 1 2.56409181e-05)
    list(7.61725e-09 0.859404824 1 2.55016054e-05)
    list(7.61925e-09 0.859570942 1 2.53988937e-05)
    list(7.62125e-09 0.859736416 1 2.53189826e-05)
    list(7.62325e-09 0.8599013 1 2.5253053e-05)
    list(7.62525e-09 0.860065645 1 2.51956888e-05)
    list(7.62725e-09 0.860229496 1 2.51436077e-05)
    list(7.62925e-09 0.860392891 1 2.50948252e-05)
    list(7.63015e-09 0.860476014 0.97 -9.44698311e-06)
    list(7.63175e-09 0.860720054 0.65 -1.96558545e-05)
    list(7.63375e-09 0.860865567 0.25 -1.56590356e-05)
    list(7.63505e-09 0.860900657 0 2.20860415e-05)
    list(7.63625e-09 0.860900623 0 2.20119692e-05)
    list(7.63825e-09 0.860900588 0 1.97682535e-05)
    list(7.64025e-09 0.860900564 0 1.87530282e-05)
    list(7.64225e-09 0.860900545 0 1.8281709e-05)
    list(7.64425e-09 0.860900528 0 1.80418097e-05)
    list(7.64625e-09 0.860900511 0 1.79063343e-05)
    list(7.64825e-09 0.860900496 0 1.78212724e-05)
    list(7.65025e-09 0.86090048 0 1.77626147e-05)
    list(7.65225e-09 0.860900465 0 1.77191247e-05)
    list(7.65425e-09 0.86090045 0 1.76851819e-05)
    list(7.65625e-09 0.860900435 0 1.76577389e-05)
    list(7.65825e-09 0.860900421 0 1.76349957e-05)
    list(7.66025e-09 0.860900406 0 1.76158028e-05)
    list(7.66225e-09 0.860900391 0 1.75993781e-05)
    list(7.66425e-09 0.860900377 0 1.75851642e-05)
    list(7.66625e-09 0.860900362 0 1.75727496e-05)
    list(7.66825e-09 0.860900347 0 1.75618228e-05)
    list(7.67025e-09 0.860900333 0 1.75521431e-05)
    list(7.67225e-09 0.860900318 0 1.75435211e-05)
    list(7.67425e-09 0.860900303 0 1.75358055e-05)
    list(7.67625e-09 0.860900289 0 1.75288732e-05)
    list(7.67825e-09 0.860900274 0 1.75226234e-05)
    list(7.68025e-09 0.860900259 0 1.75169719e-05)
    list(7.68225e-09 0.860900245 0 1.75118479e-05)
    list(7.68425e-09 0.86090023 0 1.75071913e-05)
    list(7.68625e-09 0.860900215 0 1.75029505e-05)
    list(7.68825e-09 0.860900201 0 1.74990808e-05)
    list(7.69025e-09 0.860900186 0 1.74955435e-05)
    list(7.69225e-09 0.860900171 0 1.74923047e-05)
    list(7.69425e-09 0.860900157 0 1.74893347e-05)
    list(7.69625e-09 0.860900142 0 1.74866072e-05)
    list(7.69825e-09 0.860900128 0 1.74840991e-05)
    list(7.7e-09 0.860900115 0 1.74812422e-05)
    list(7.70075e-09 0.860881751 0.15 2.75116317e-05)
    list(7.70275e-09 0.860824065 0.55 5.56193851e-05)
    list(7.70475e-09 0.860865684 0.95 6.36077968e-05)
    list(7.70535e-09 0.860891665 1 2.47212715e-05)
    list(7.70725e-09 0.861032313 1 2.63139232e-05)
    list(7.70925e-09 0.861194258 1 2.62547293e-05)
    list(7.71125e-09 0.861359458 1 2.59465763e-05)
    list(7.71325e-09 0.861524979 1 2.56749857e-05)
    list(7.71525e-09 0.861690021 1 2.54750592e-05)
    list(7.71725e-09 0.861854398 1 2.53311758e-05)
    list(7.71925e-09 0.862018099 1 2.52243922e-05)
    list(7.72125e-09 0.862181167 1 2.51409194e-05)
    list(7.72325e-09 0.862343652 1 2.50718903e-05)
    list(7.72525e-09 0.862505604 1 2.50118356e-05)
    list(7.72725e-09 0.862667067 1 2.49574241e-05)
    list(7.72925e-09 0.862828081 1 2.49066285e-05)
    list(7.73015e-09 0.862910181 0.97 -9.7626524e-06)
    list(7.73175e-09 0.863153912 0.65 -1.97297582e-05)
    list(7.73375e-09 0.863300364 0.25 -1.57190178e-05)
    list(7.73505e-09 0.863335701 0 2.20771632e-05)
    list(7.73625e-09 0.863335667 0 2.19968378e-05)
    list(7.73825e-09 0.863335631 0 1.9749731e-05)
    list(7.74025e-09 0.863335607 0 1.87356997e-05)
    list(7.74225e-09 0.863335588 0 1.82672308e-05)
    list(7.74425e-09 0.86333557 0 1.80304116e-05)
    list(7.74625e-09 0.863335554 0 1.78976631e-05)
    list(7.74825e-09 0.863335538 0 1.78148083e-05)
    list(7.75025e-09 0.863335523 0 1.77578511e-05)
    list(7.75225e-09 0.863335507 0 1.77156325e-05)
    list(7.75425e-09 0.863335492 0 1.76826219e-05)
    list(7.75625e-09 0.863335477 0 1.7655853e-05)
    list(7.75825e-09 0.863335462 0 1.7633593e-05)
    list(7.76025e-09 0.863335447 0 1.7614744e-05)
    list(7.76225e-09 0.863335433 0 1.75985631e-05)
    list(7.76425e-09 0.863335418 0 1.75845214e-05)
    list(7.76625e-09 0.863335403 0 1.75722283e-05)
    list(7.76825e-09 0.863335388 0 1.75613873e-05)
    list(7.77025e-09 0.863335373 0 1.75517683e-05)
    list(7.77225e-09 0.863335359 0 1.75431894e-05)
    list(7.77425e-09 0.863335344 0 1.75355046e-05)
    list(7.77625e-09 0.863335329 0 1.75285947e-05)
    list(7.77825e-09 0.863335314 0 1.75223613e-05)
    list(7.78025e-09 0.8633353 0 1.75167222e-05)
    list(7.78225e-09 0.863335285 0 1.75116079e-05)
    list(7.78425e-09 0.86333527 0 1.7506959e-05)
    list(7.78625e-09 0.863335255 0 1.75027246e-05)
    list(7.78825e-09 0.86333524 0 1.74988605e-05)
    list(7.79025e-09 0.863335226 0 1.74953282e-05)
    list(7.79225e-09 0.863335211 0 1.7492094e-05)
    list(7.79425e-09 0.863335196 0 1.74891284e-05)
    list(7.79625e-09 0.863335181 0 1.74864051e-05)
    list(7.79825e-09 0.863335166 0 1.7483901e-05)
    list(7.8e-09 0.863335153 0 1.74810489e-05)
    list(7.80075e-09 0.86331664 0.15 2.75172056e-05)
    list(7.80275e-09 0.863258499 0.55 5.54047481e-05)
    list(7.80475e-09 0.863295399 0.95 6.35096751e-05)
    list(7.80535e-09 0.863319664 1 2.40607236e-05)
    list(7.80725e-09 0.863456354 1 2.57037457e-05)
    list(7.80925e-09 0.863615342 1 2.57119179e-05)
    list(7.81125e-09 0.863777955 1 2.54267146e-05)
    list(7.81325e-09 0.863941005 1 2.51665508e-05)
    list(7.81525e-09 0.864103619 1 2.49745771e-05)
    list(7.81725e-09 0.86426559 1 2.4837179e-05)
    list(7.81925e-09 0.864426898 1 2.47359592e-05)
    list(7.82125e-09 0.864587582 1 2.46573263e-05)
    list(7.82325e-09 0.86474769 1 2.45925248e-05)
    list(7.82525e-09 0.864907273 1 2.45361709e-05)
    list(7.82725e-09 0.865066372 1 2.44850057e-05)
    list(7.82925e-09 0.865225025 1 2.44370643e-05)
    list(7.83015e-09 0.865306113 0.97 -1.00738634e-05)
    list(7.83175e-09 0.865549525 0.65 -1.98026402e-05)
    list(7.83375e-09 0.865696901 0.25 -1.5776034e-05)
    list(7.83505e-09 0.86573248 0 2.20679726e-05)
    list(7.83625e-09 0.865732445 0 2.1981536e-05)
    list(7.83825e-09 0.86573241 0 1.97312851e-05)
    list(7.84025e-09 0.865732386 0 1.8718601e-05)
    list(7.84225e-09 0.865732366 0 1.82530304e-05)
    list(7.84425e-09 0.865732349 0 1.80192754e-05)
    list(7.84625e-09 0.865732332 0 1.78892113e-05)
    list(7.84825e-09 0.865732316 0 1.78085158e-05)
    list(7.85025e-09 0.8657323 0 1.77532158e-05)
    list(7.85225e-09 0.865732285 0 1.77122331e-05)
    list(7.85425e-09 0.86573227 0 1.76801268e-05)
    list(7.85625e-09 0.865732255 0 1.76540115e-05)
    list(7.85825e-09 0.86573224 0 1.76322194e-05)
    list(7.86025e-09 0.865732225 0 1.76137035e-05)
    list(7.86225e-09 0.86573221 0 1.75977587e-05)
    list(7.86425e-09 0.865732195 0 1.7583884e-05)
    list(7.86625e-09 0.86573218 0 1.75717088e-05)
    list(7.86825e-09 0.865732165 0 1.75609512e-05)
    list(7.87025e-09 0.86573215 0 1.75513913e-05)
    list(7.87225e-09 0.865732135 0 1.75428545e-05)
    list(7.87425e-09 0.86573212 0 1.75351999e-05)
    list(7.87625e-09 0.865732105 0 1.7528312e-05)
    list(7.87825e-09 0.86573209 0 1.75220949e-05)
    list(7.88025e-09 0.865732075 0 1.75164682e-05)
    list(7.88225e-09 0.86573206 0 1.75113636e-05)
    list(7.88425e-09 0.865732045 0 1.75067225e-05)
    list(7.88625e-09 0.86573203 0 1.75024947e-05)
    list(7.88825e-09 0.865732015 0 1.74986363e-05)
    list(7.89025e-09 0.865732 0 1.74951091e-05)
    list(7.89225e-09 0.865731985 0 1.74918797e-05)
    list(7.89425e-09 0.865731971 0 1.74889185e-05)
    list(7.89625e-09 0.865731956 0 1.74861995e-05)
    list(7.89825e-09 0.865731941 0 1.74836996e-05)
    list(7.9e-09 0.865731928 0 1.74808525e-05)
    list(7.90075e-09 0.865713265 0.15 2.75226942e-05)
    list(7.90275e-09 0.865654672 0.55 5.51871403e-05)
    list(7.90475e-09 0.865686878 0.95 6.34084991e-05)
    list(7.90535e-09 0.865709458 1 2.34105281e-05)
    list(7.90725e-09 0.865842251 1 2.50806672e-05)
    list(7.90925e-09 0.86599832 1 2.51558926e-05)
    list(7.91125e-09 0.866158376 1 2.48939129e-05)
    list(7.91325e-09 0.86631898 1 2.4645637e-05)
    list(7.91525e-09 0.866479192 1 2.4462088e-05)
    list(7.91725e-09 0.86663878 1 2.43316059e-05)
    list(7.91925e-09 0.86679772 1 2.42363301e-05)
    list(7.92125e-09 0.866956043 1 2.41628694e-05)
    list(7.92325e-09 0.867113799 1 2.4102585e-05)
    list(7.92525e-09 0.867271035 1 2.40501841e-05)
    list(7.92725e-09 0.867427793 1 2.4002485e-05)
    list(7.92925e-09 0.86758411 1 2.39575892e-05)
    list(7.93015e-09 0.867664195 0.97 -1.0382507e-05)
    list(7.93175e-09 0.867907276 0.65 -1.98760555e-05)
    list(7.93375e-09 0.868055564 0.25 -1.58311552e-05)
    list(7.93505e-09 0.86809138 0 2.20585671e-05)
    list(7.93625e-09 0.868091346 0 2.19661433e-05)
    list(7.93825e-09 0.86809131 0 1.97129851e-05)
    list(7.94025e-09 0.868091286 0 1.87017846e-05)
    list(7.94225e-09 0.868091266 0 1.82391467e-05)
    list(7.94425e-09 0.868091248 0 1.80084311e-05)
    list(7.94625e-09 0.868091231 0 1.78810035e-05)
    list(7.94825e-09 0.868091215 0 1.78024159e-05)
    list(7.95025e-09 0.868091199 0 1.77487272e-05)
    list(7.95225e-09 0.868091184 0 1.77089425e-05)
    list(7.95425e-09 0.868091169 0 1.7677711e-05)
    list(7.95625e-09 0.868091153 0 1.76522266e-05)
    list(7.95825e-09 0.868091138 0 1.76308856e-05)
    list(7.96025e-09 0.868091123 0 1.76126904e-05)
    list(7.96225e-09 0.868091108 0 1.75969727e-05)
    list(7.96425e-09 0.868091093 0 1.75832583e-05)
    list(7.96625e-09 0.868091078 0 1.75711963e-05)
    list(7.96825e-09 0.868091063 0 1.75605185e-05)
    list(7.97025e-09 0.868091047 0 1.75510152e-05)
    list(7.97225e-09 0.868091032 0 1.75425186e-05)
    list(7.97425e-09 0.868091017 0 1.75348929e-05)
    list(7.97625e-09 0.868091002 0 1.75280261e-05)
    list(7.97825e-09 0.868090987 0 1.75218246e-05)
    list(7.98025e-09 0.868090972 0 1.75162097e-05)
    list(7.98225e-09 0.868090957 0 1.75111143e-05)
    list(7.98425e-09 0.868090942 0 1.75064808e-05)
    list(7.98625e-09 0.868090927 0 1.75022593e-05)
    list(7.98825e-09 0.868090912 0 1.74984065e-05)
    list(7.99025e-09 0.868090897 0 1.74948843e-05)
    list(7.99225e-09 0.868090882 0 1.74916596e-05)
    list(7.99425e-09 0.868090866 0 1.74887028e-05)
    list(7.99625e-09 0.868090851 0 1.74859881e-05)
    list(7.99825e-09 0.868090836 0 1.74834923e-05)
    list(8e-09 0.868090823 0 1.74806501e-05)
    list(8.00075e-09 0.868072015 0.15 2.75280979e-05)
    list(8.00275e-09 0.868012969 0.55 5.49666397e-05)
    list(8.00475e-09 0.86804051 0.95 6.33042879e-05)
    list(8.00535e-09 0.868061432 1 2.27706076e-05)
    list(8.00725e-09 0.868190389 1 2.44675631e-05)
    list(8.00925e-09 0.868343577 1 2.46084646e-05)
    list(8.01125e-09 0.868501104 1 2.43691221e-05)
    list(8.01325e-09 0.86865929 1 2.41324315e-05)
    list(8.01525e-09 0.868817124 1 2.39571084e-05)
    list(8.01725e-09 0.868974355 1 2.38333876e-05)
    list(8.01925e-09 0.869130949 1 2.37439254e-05)
    list(8.02125e-09 0.869286936 1 2.36755238e-05)
    list(8.02325e-09 0.869442363 1 2.36196578e-05)
    list(8.02525e-09 0.869597276 1 2.35711233e-05)
    list(8.02725e-09 0.869751716 1 2.35268144e-05)
    list(8.02925e-09 0.86990572 1 2.34848979e-05)
    list(8.03015e-09 0.869984812 0.97 -1.06886596e-05)
    list(8.03175e-09 0.870227554 0.65 -1.99500575e-05)
    list(8.03375e-09 0.870376738 0.25 -1.58841527e-05)
    list(8.03505e-09 0.870412788 0 2.20489712e-05)
    list(8.03625e-09 0.870412753 0 2.19506846e-05)
    list(8.03825e-09 0.870412717 0 1.96948474e-05)
    list(8.04025e-09 0.870412693 0 1.86852552e-05)
    list(8.04225e-09 0.870412673 0 1.82255763e-05)
    list(8.04425e-09 0.870412655 0 1.79978721e-05)
    list(8.04625e-09 0.870412638 0 1.78730321e-05)
    list(8.04825e-09 0.870412622 0 1.77965018e-05)
    list(8.05025e-09 0.870412606 0 1.77443794e-05)
    list(8.05225e-09 0.870412591 0 1.77057558e-05)
    list(8.05425e-09 0.870412575 0 1.76753703e-05)
    list(8.05625e-09 0.87041256 0 1.76504949e-05)
    list(8.05825e-09 0.870412544 0 1.76295887e-05)
    list(8.06025e-09 0.870412529 0 1.76117022e-05)
    list(8.06225e-09 0.870412514 0 1.75962026e-05)
    list(8.06425e-09 0.870412498 0 1.75826421e-05)
    list(8.06625e-09 0.870412483 0 1.75706885e-05)
    list(8.06825e-09 0.870412468 0 1.75600873e-05)
    list(8.07025e-09 0.870412453 0 1.7550638e-05)
    list(8.07225e-09 0.870412438 0 1.75421799e-05)
    list(8.07425e-09 0.870412422 0 1.75345818e-05)
    list(8.07625e-09 0.870412407 0 1.75277349e-05)
    list(8.07825e-09 0.870412392 0 1.75215483e-05)
    list(8.08025e-09 0.870412377 0 1.75159447e-05)
    list(8.08225e-09 0.870412361 0 1.75108582e-05)
    list(8.08425e-09 0.870412346 0 1.75062319e-05)
    list(8.08625e-09 0.870412331 0 1.75020165e-05)
    list(8.08825e-09 0.870412316 0 1.74981691e-05)
    list(8.09025e-09 0.8704123 0 1.74946518e-05)
    list(8.09225e-09 0.870412285 0 1.74914316e-05)
    list(8.09425e-09 0.87041227 0 1.74884792e-05)
    list(8.09625e-09 0.870412255 0 1.74857687e-05)
    list(8.09825e-09 0.87041224 0 1.74832771e-05)
    list(8.1e-09 0.870412226 0 1.74804399e-05)
    list(8.10075e-09 0.870393274 0.15 2.75334172e-05)
    list(8.10275e-09 0.870333776 0.55 5.47433292e-05)
    list(8.10475e-09 0.870356682 0.95 6.31971519e-05)
    list(8.10535e-09 0.870375974 1 2.21408801e-05)
    list(8.10725e-09 0.870501192 1 2.39365382e-05)
    list(8.10925e-09 0.870651501 1 2.42004333e-05)
    list(8.11125e-09 0.870806528 1 2.39779722e-05)
    list(8.11325e-09 0.87096232 1 2.3747879e-05)
    list(8.11525e-09 0.871117802 1 2.35764524e-05)
    list(8.11725e-09 0.8712727 1 2.34557253e-05)
    list(8.11925e-09 0.871426972 1 2.33687944e-05)
    list(8.12125e-09 0.871580648 1 2.33025906e-05)
    list(8.12325e-09 0.87173377 1 2.32486483e-05)
    list(8.12525e-09 0.871886383 1 2.32018048e-05)
    list(8.12725e-09 0.87203853 1 2.31589885e-05)
    list(8.12925e-09 0.872190245 1 2.31183954e-05)
    list(8.13015e-09 0.872268354 0.97 -1.09929432e-05)
    list(8.13175e-09 0.872510747 0.65 -2.00251461e-05)
    list(8.13375e-09 0.872660814 0.25 -1.593524e-05)
    list(8.13505e-09 0.872697094 0 2.20392343e-05)
    list(8.13625e-09 0.872697059 0 2.19352027e-05)
    list(8.13825e-09 0.872697022 0 1.96769039e-05)
    list(8.14025e-09 0.872696998 0 1.86690311e-05)
    list(8.14225e-09 0.872696978 0 1.82123286e-05)
    list(8.14425e-09 0.87269696 0 1.79876027e-05)
    list(8.14625e-09 0.872696943 0 1.78652999e-05)
    list(8.14825e-09 0.872696926 0 1.77907753e-05)
    list(8.15025e-09 0.87269691 0 1.7740174e-05)
    list(8.15225e-09 0.872696894 0 1.77026748e-05)
    list(8.15425e-09 0.872696879 0 1.76731064e-05)
    list(8.15625e-09 0.872696863 0 1.7648818e-05)
    list(8.15825e-09 0.872696848 0 1.76283302e-05)
    list(8.16025e-09 0.872696832 0 1.761074e-05)
    list(8.16225e-09 0.872696817 0 1.75954495e-05)
    list(8.16425e-09 0.872696802 0 1.75820362e-05)
    list(8.16625e-09 0.872696786 0 1.75701861e-05)
    list(8.16825e-09 0.872696771 0 1.75596576e-05)
    list(8.17025e-09 0.872696755 0 1.75502596e-05)
    list(8.17225e-09 0.87269674 0 1.75418379e-05)
    list(8.17425e-09 0.872696725 0 1.75342658e-05)
    list(8.17625e-09 0.872696709 0 1.75274378e-05)
    list(8.17825e-09 0.872696694 0 1.75212651e-05)
    list(8.18025e-09 0.872696679 0 1.75156721e-05)
    list(8.18225e-09 0.872696663 0 1.75105939e-05)
    list(8.18425e-09 0.872696648 0 1.75059744e-05)
    list(8.18625e-09 0.872696632 0 1.75017648e-05)
    list(8.18825e-09 0.872696617 0 1.74979225e-05)
    list(8.19025e-09 0.872696602 0 1.749441e-05)
    list(8.19225e-09 0.872696586 0 1.74911942e-05)
    list(8.19425e-09 0.872696571 0 1.74882461e-05)
    list(8.19625e-09 0.872696556 0 1.74855397e-05)
    list(8.19825e-09 0.87269654 0 1.74830521e-05)
    list(8.2e-09 0.872696527 0 1.74802199e-05)
    list(8.20075e-09 0.872677433 0.15 2.75386526e-05)
    list(8.20275e-09 0.872617484 0.55 5.45172956e-05)
    list(8.20475e-09 0.872635784 0.95 6.3087283e-05)
    list(8.20535e-09 0.872653475 1 2.15212572e-05)
    list(8.20725e-09 0.872775056 1 2.34936936e-05)
    list(8.20925e-09 0.872922483 1 2.39418777e-05)
    list(8.21125e-09 0.873075037 1 2.37301311e-05)
    list(8.21325e-09 0.873228463 1 2.35012755e-05)
    list(8.21525e-09 0.873381617 1 2.33290881e-05)
    list(8.21725e-09 0.873534207 1 2.32073012e-05)
    list(8.21925e-09 0.873686184 1 2.31193705e-05)
    list(8.22125e-09 0.873837571 1 2.30522878e-05)
    list(8.22325e-09 0.873988412 1 2.29975875e-05)
    list(8.22525e-09 0.874138751 1 2.29500973e-05)
    list(8.22725e-09 0.874288628 1 2.29067354e-05)
    list(8.22925e-09 0.874438078 1 2.28656881e-05)
    list(8.23015e-09 0.874515213 0.97 -1.12953767e-05)
    list(8.23175e-09 0.87475725 0.65 -2.0101318e-05)
    list(8.23375e-09 0.874908186 0.25 -1.59842331e-05)
    list(8.23505e-09 0.874944691 0 2.20293764e-05)
    list(8.23625e-09 0.874944655 0 2.19197183e-05)
    list(8.23825e-09 0.874944618 0 1.96591661e-05)
    list(8.24025e-09 0.874944594 0 1.86531134e-05)
    list(8.24225e-09 0.874944574 0 1.8199398e-05)
    list(8.24425e-09 0.874944556 0 1.79776153e-05)
    list(8.24625e-09 0.874944538 0 1.78577987e-05)
    list(8.24825e-09 0.874944522 0 1.77852293e-05)
    list(8.25025e-09 0.874944506 0 1.77361051e-05)
    list(8.25225e-09 0.87494449 0 1.76996945e-05)
    list(8.25425e-09 0.874944474 0 1.76709153e-05)
    list(8.25625e-09 0.874944458 0 1.76471927e-05)
    list(8.25825e-09 0.874944443 0 1.76271072e-05)
    list(8.26025e-09 0.874944427 0 1.76098014e-05)
    list(8.26225e-09 0.874944412 0 1.75947112e-05)
    list(8.26425e-09 0.874944396 0 1.75814386e-05)
    list(8.26625e-09 0.87494438 0 1.75696871e-05)
    list(8.26825e-09 0.874944365 0 1.75592278e-05)
    list(8.27025e-09 0.874944349 0 1.75498784e-05)
    list(8.27225e-09 0.874944334 0 1.75414911e-05)
    list(8.27425e-09 0.874944318 0 1.75339434e-05)
    list(8.27625e-09 0.874944303 0 1.75271331e-05)
    list(8.27825e-09 0.874944287 0 1.75209735e-05)
    list(8.28025e-09 0.874944272 0 1.75153904e-05)
    list(8.28225e-09 0.874944256 0 1.751032e-05)
    list(8.28425e-09 0.874944241 0 1.75057069e-05)
    list(8.28625e-09 0.874944225 0 1.75015029e-05)
    list(8.28825e-09 0.87494421 0 1.74976654e-05)
    list(8.29025e-09 0.874944194 0 1.74941574e-05)
    list(8.29225e-09 0.874944179 0 1.7490946e-05)
    list(8.29425e-09 0.874944163 0 1.7488002e-05)
    list(8.29625e-09 0.874944148 0 1.74852997e-05)
    list(8.29825e-09 0.874944132 0 1.74828162e-05)
    list(8.3e-09 0.874944119 0 1.74799888e-05)
    list(8.30075e-09 0.874924886 0.15 2.75438045e-05)
    list(8.30275e-09 0.874864485 0.55 5.42886281e-05)
    list(8.30475e-09 0.874878213 0.95 6.29749437e-05)
    list(8.30535e-09 0.874894329 1 2.09116452e-05)
    list(8.30725e-09 0.875012331 1 2.30569284e-05)
    list(8.30925e-09 0.875156916 1 2.36844311e-05)
    list(8.31125e-09 0.875307027 1 2.34830775e-05)
    list(8.31325e-09 0.875458113 1 2.32554113e-05)
    list(8.31525e-09 0.875608966 1 2.30824906e-05)
    list(8.31725e-09 0.875759273 1 2.29596881e-05)
    list(8.31925e-09 0.875908978 1 2.28708018e-05)
    list(8.32125e-09 0.876058102 1 2.28028805e-05)
    list(8.32325e-09 0.876206687 1 2.27474586e-05)
    list(8.32525e-09 0.876354775 1 2.26993543e-05)
    list(8.32725e-09 0.876502406 1 2.26554759e-05)
    list(8.32925e-09 0.876649615 1 2.26140004e-05)
    list(8.33015e-09 0.876725788 0.97 -1.15951891e-05)
    list(8.33175e-09 0.876967459 0.65 -2.01779136e-05)
    list(8.33375e-09 0.877119249 0.25 -1.60304121e-05)
    list(8.33505e-09 0.877155976 0 2.20193804e-05)
    list(8.33625e-09 0.87715594 0 2.19042245e-05)
    list(8.33825e-09 0.877155903 0 1.96416207e-05)
    list(8.34025e-09 0.877155878 0 1.8637481e-05)
    list(8.34225e-09 0.877155858 0 1.81867603e-05)
    list(8.34425e-09 0.87715584 0 1.79678857e-05)
    list(8.34625e-09 0.877155822 0 1.78505068e-05)
    list(8.34825e-09 0.877155806 0 1.77798446e-05)
    list(8.35025e-09 0.877155789 0 1.77321563e-05)
    list(8.35225e-09 0.877155773 0 1.7696801e-05)
    list(8.35425e-09 0.877155757 0 1.76687852e-05)
    list(8.35625e-09 0.877155742 0 1.76456088e-05)
    list(8.35825e-09 0.877155726 0 1.76259111e-05)
    list(8.36025e-09 0.87715571 0 1.76088792e-05)
    list(8.36225e-09 0.877155694 0 1.75939815e-05)
    list(8.36425e-09 0.877155679 0 1.75808439e-05)
    list(8.36625e-09 0.877155663 0 1.75691869e-05)
    list(8.36825e-09 0.877155647 0 1.75587938e-05)
    list(8.37025e-09 0.877155632 0 1.75494909e-05)
    list(8.37225e-09 0.877155616 0 1.75411363e-05)
    list(8.37425e-09 0.8771556 0 1.75336119e-05)
    list(8.37625e-09 0.877155585 0 1.75268185e-05)
    list(8.37825e-09 0.877155569 0 1.75206713e-05)
    list(8.38025e-09 0.877155553 0 1.75150977e-05)
    list(8.38225e-09 0.877155538 0 1.75100348e-05)
    list(8.38425e-09 0.877155522 0 1.75054279e-05)
    list(8.38625e-09 0.877155506 0 1.75012292e-05)
    list(8.38825e-09 0.877155491 0 1.74973965e-05)
    list(8.39025e-09 0.877155475 0 1.7493893e-05)
    list(8.39225e-09 0.877155459 0 1.74906858e-05)
    list(8.39425e-09 0.877155444 0 1.7487746e-05)
    list(8.39625e-09 0.877155428 0 1.74850478e-05)
    list(8.39825e-09 0.877155412 0 1.74825683e-05)
    list(8.4e-09 0.877155399 0 1.7479746e-05)
    list(8.40075e-09 0.877136029 0.15 2.75488736e-05)
    list(8.40275e-09 0.877075176 0.55 5.40574174e-05)
    list(8.40475e-09 0.877084364 0.95 6.28605488e-05)
    list(8.40535e-09 0.877098933 1 2.03118816e-05)
    list(8.40725e-09 0.87721341 1 2.2626159e-05)
    list(8.40925e-09 0.877355193 1 2.34285126e-05)
    list(8.41125e-09 0.877502891 1 2.32372816e-05)
    list(8.41325e-09 0.877651664 1 2.30107592e-05)
    list(8.41525e-09 0.877800241 1 2.28371238e-05)
    list(8.41725e-09 0.877948289 1 2.27133385e-05)
    list(8.41925e-09 0.878095747 1 2.26235303e-05)
    list(8.42125e-09 0.878242633 1 2.25548016e-05)
    list(8.42325e-09 0.878388986 1 2.24986863e-05)
    list(8.42525e-09 0.878534848 1 2.24499933e-05)
    list(8.42725e-09 0.878680258 1 2.24056213e-05)
    list(8.42925e-09 0.87882525 1 2.23637382e-05)
    list(8.43015e-09 0.87890047 0.97 -1.18923519e-05)
    list(8.43175e-09 0.879141769 0.65 -2.02548872e-05)
    list(8.43375e-09 0.879294399 0.25 -1.60736346e-05)
    list(8.43505e-09 0.879331343 0 2.20092685e-05)
    list(8.43625e-09 0.879331307 0 2.18887422e-05)
    list(8.43825e-09 0.87933127 0 1.96242767e-05)
    list(8.44025e-09 0.879331245 0 1.86221328e-05)
    list(8.44225e-09 0.879331225 0 1.8174409e-05)
    list(8.44425e-09 0.879331206 0 1.79584057e-05)
    list(8.44625e-09 0.879331189 0 1.78434161e-05)
    list(8.44825e-09 0.879331172 0 1.77746144e-05)
    list(8.45025e-09 0.879331156 0 1.77283217e-05)
    list(8.45225e-09 0.879331139 0 1.76939895e-05)
    list(8.45425e-09 0.879331123 0 1.76667123e-05)
    list(8.45625e-09 0.879331107 0 1.76440634e-05)
    list(8.45825e-09 0.879331091 0 1.76247396e-05)
    list(8.46025e-09 0.879331076 0 1.76079713e-05)
    list(8.46225e-09 0.87933106 0 1.75932587e-05)
    list(8.46425e-09 0.879331044 0 1.75802506e-05)
    list(8.46625e-09 0.879331028 0 1.75686842e-05)
    list(8.46825e-09 0.879331012 0 1.75583544e-05)
    list(8.47025e-09 0.879330996 0 1.75490959e-05)
    list(8.47225e-09 0.879330981 0 1.75407725e-05)
    list(8.47425e-09 0.879330965 0 1.75332704e-05)
    list(8.47625e-09 0.879330949 0 1.75264929e-05)
    list(8.47825e-09 0.879330933 0 1.75203576e-05)
    list(8.48025e-09 0.879330917 0 1.75147931e-05)
    list(8.48225e-09 0.879330901 0 1.75097374e-05)
    list(8.48425e-09 0.879330886 0 1.75051365e-05)
    list(8.48625e-09 0.87933087 0 1.75009429e-05)
    list(8.48825e-09 0.879330854 0 1.7497115e-05)
    list(8.49025e-09 0.879330838 0 1.74936159e-05)
    list(8.49225e-09 0.879330822 0 1.7490413e-05)
    list(8.49425e-09 0.879330807 0 1.74874773e-05)
    list(8.49625e-09 0.879330791 0 1.74847832e-05)
    list(8.49825e-09 0.879330775 0 1.74823079e-05)
    list(8.5e-09 0.879330761 0 1.74794906e-05)
    list(8.50075e-09 0.879311256 0.15 2.75538605e-05)
    list(8.50275e-09 0.879249952 0.55 5.38237558e-05)
    list(8.50475e-09 0.879254637 0.95 6.2744283e-05)
    list(8.50535e-09 0.879267686 1 1.97219944e-05)
    list(8.50725e-09 0.879378696 1 2.22014197e-05)
    list(8.50925e-09 0.879517715 1 2.31740203e-05)
    list(8.51125e-09 0.879663029 1 2.29926255e-05)
    list(8.51325e-09 0.879809516 1 2.27672045e-05)
    list(8.51525e-09 0.879955843 1 2.25928784e-05)
    list(8.51725e-09 0.880101659 1 2.24681486e-05)
    list(8.51925e-09 0.880246895 1 2.23774567e-05)
    list(8.52125e-09 0.880391567 1 2.23079557e-05)
    list(8.52325e-09 0.880535713 1 2.22511785e-05)
    list(8.52525e-09 0.880679373 1 2.2201925e-05)
    list(8.52725e-09 0.880822586 1 2.21570847e-05)
    list(8.52925e-09 0.880965386 1 2.21148166e-05)
    list(8.53015e-09 0.881039663 0.97 -1.21868346e-05)
    list(8.53175e-09 0.881280583 0.65 -2.03321894e-05)
    list(8.53375e-09 0.881434039 0.25 -1.61137973e-05)
    list(8.53505e-09 0.881471197 0 2.1999062e-05)
    list(8.53625e-09 0.88147116 0 2.18732903e-05)
    list(8.53825e-09 0.881471123 0 1.96071415e-05)
    list(8.54025e-09 0.881471098 0 1.86070665e-05)
    list(8.54225e-09 0.881471078 0 1.81623369e-05)
    list(8.54425e-09 0.881471059 0 1.79491671e-05)
    list(8.54625e-09 0.881471041 0 1.78365188e-05)
    list(8.54825e-09 0.881471024 0 1.77695318e-05)
    list(8.55025e-09 0.881471008 0 1.7724596e-05)
    list(8.55225e-09 0.881470991 0 1.76912558e-05)
    list(8.55425e-09 0.881470975 0 1.76646932e-05)
    list(8.55625e-09 0.881470959 0 1.76425538e-05)
    list(8.55825e-09 0.881470943 0 1.76235906e-05)
    list(8.56025e-09 0.881470927 0 1.76070759e-05)
    list(8.56225e-09 0.881470911 0 1.75925413e-05)
    list(8.56425e-09 0.881470895 0 1.75796575e-05)
    list(8.56625e-09 0.881470879 0 1.75681779e-05)
    list(8.56825e-09 0.881470863 0 1.75579087e-05)
    list(8.57025e-09 0.881470847 0 1.75486925e-05)
    list(8.57225e-09 0.881470831 0 1.75403989e-05)
    list(8.57425e-09 0.881470815 0 1.7532918e-05)
    list(8.57625e-09 0.881470799 0 1.75261558e-05)
    list(8.57825e-09 0.881470783 0 1.75200318e-05)
    list(8.58025e-09 0.881470767 0 1.75144759e-05)
    list(8.58225e-09 0.881470751 0 1.75094271e-05)
    list(8.58425e-09 0.881470735 0 1.7504832e-05)
    list(8.58625e-09 0.881470719 0 1.75006435e-05)
    list(8.58825e-09 0.881470703 0 1.74968202e-05)
    list(8.59025e-09 0.881470687 0 1.74933255e-05)
    list(8.59225e-09 0.881470671 0 1.74901268e-05)
    list(8.59425e-09 0.881470655 0 1.74871954e-05)
    list(8.59625e-09 0.881470639 0 1.74845054e-05)
    list(8.59825e-09 0.881470623 0 1.74820342e-05)
    list(8.6e-09 0.88147061 0 1.7479222e-05)
    list(8.60075e-09 0.881450972 0.15 2.75587659e-05)
    list(8.60275e-09 0.881389216 0.55 5.3587735e-05)
    list(8.60475e-09 0.881389435 0.95 6.2626645e-05)
    list(8.60535e-09 0.88140099 1 1.91418124e-05)
    list(8.60725e-09 0.881508588 1 2.17826519e-05)
    list(8.60925e-09 0.881644887 1 2.27600825e-05)
    list(8.61125e-09 0.881787844 1 2.2595658e-05)
    list(8.61325e-09 0.881932071 1 2.23774209e-05)
    list(8.61525e-09 0.882076173 1 2.22076759e-05)
    list(8.61725e-09 0.882219782 1 2.20865875e-05)
    list(8.61925e-09 0.882362821 1 2.19990049e-05)
    list(8.62125e-09 0.882505304 1 2.19322098e-05)
    list(8.62325e-09 0.882647267 1 2.18778008e-05)
    list(8.62525e-09 0.882788751 1 2.18306273e-05)
    list(8.62725e-09 0.882929792 1 2.17876203e-05)
    list(8.62925e-09 0.883070424 1 2.17469741e-05)
    list(8.63015e-09 0.883143769 0.97 -1.24777957e-05)
    list(8.63175e-09 0.883384302 0.65 -2.04090938e-05)
    list(8.63375e-09 0.88353857 0.25 -1.61502391e-05)
    list(8.63505e-09 0.883575938 0 2.19887456e-05)
    list(8.63625e-09 0.883575901 0 2.185786e-05)
    list(8.63825e-09 0.883575863 0 1.95901968e-05)
    list(8.64025e-09 0.883575838 0 1.85921785e-05)
    list(8.64225e-09 0.883575818 0 1.81505148e-05)
    list(8.64425e-09 0.883575799 0 1.79401432e-05)
    list(8.64625e-09 0.883575781 0 1.78297918e-05)
    list(8.64825e-09 0.883575764 0 1.77645773e-05)
    list(8.65025e-09 0.883575747 0 1.77209626e-05)
    list(8.65225e-09 0.883575731 0 1.76885861e-05)
    list(8.65425e-09 0.883575714 0 1.76627165e-05)
    list(8.65625e-09 0.883575698 0 1.76410705e-05)
    list(8.65825e-09 0.883575682 0 1.7622456e-05)
    list(8.66025e-09 0.883575666 0 1.76061867e-05)
    list(8.66225e-09 0.883575649 0 1.75918239e-05)
    list(8.66425e-09 0.883575633 0 1.75790602e-05)
    list(8.66625e-09 0.883575617 0 1.75676644e-05)
    list(8.66825e-09 0.883575601 0 1.75574536e-05)
    list(8.67025e-09 0.883575585 0 1.75482783e-05)
    list(8.67225e-09 0.883575569 0 1.75400135e-05)
    list(8.67425e-09 0.883575553 0 1.75325531e-05)
    list(8.67625e-09 0.883575537 0 1.75258058e-05)
    list(8.67825e-09 0.88357552 0 1.75196928e-05)
    list(8.68025e-09 0.883575504 0 1.75141454e-05)
    list(8.68225e-09 0.883575488 0 1.75091034e-05)
    list(8.68425e-09 0.883575472 0 1.75045141e-05)
    list(8.68625e-09 0.883575456 0 1.75003307e-05)
    list(8.68825e-09 0.88357544 0 1.74965121e-05)
    list(8.69025e-09 0.883575424 0 1.74930218e-05)
    list(8.69225e-09 0.883575408 0 1.74898275e-05)
    list(8.69425e-09 0.883575392 0 1.74869003e-05)
    list(8.69625e-09 0.883575375 0 1.74842146e-05)
    list(8.69825e-09 0.883575359 0 1.74817476e-05)
    list(8.7e-09 0.883575345 0 1.74789407e-05)
    list(8.70075e-09 0.883555577 0.15 2.75635904e-05)
    list(8.70275e-09 0.883493368 0.55 5.33494459e-05)
    list(8.70475e-09 0.883489159 0.95 6.25080636e-05)
    list(8.70535e-09 0.883499247 1 1.85712269e-05)
    list(8.70725e-09 0.883603488 1 2.13698181e-05)
    list(8.70925e-09 0.883737108 1 2.23224522e-05)
    list(8.71125e-09 0.883877737 1 2.21759112e-05)
    list(8.71325e-09 0.88401973 1 2.19657963e-05)
    list(8.71525e-09 0.884161634 1 2.18014915e-05)
    list(8.71725e-09 0.88430306 1 2.16848037e-05)
    list(8.71925e-09 0.884443928 1 2.16009941e-05)
    list(8.72125e-09 0.884584247 1 2.1537483e-05)
    list(8.72325e-09 0.884724053 1 2.14859458e-05)
    list(8.72525e-09 0.884863384 1 2.1441291e-05)
    list(8.72725e-09 0.885002278 1 2.14004993e-05)
    list(8.72925e-09 0.885140767 1 2.1361808e-05)
    list(8.73015e-09 0.885213189 0.97 -1.27658916e-05)
    list(8.73175e-09 0.88545333 0.65 -2.048613e-05)
    list(8.73375e-09 0.885608397 0.25 -1.61834228e-05)
    list(8.73505e-09 0.88564597 0 2.19783778e-05)
    list(8.73625e-09 0.885645933 0 2.18424946e-05)
    list(8.73825e-09 0.885645895 0 1.95734694e-05)
    list(8.74025e-09 0.88564587 0 1.85776418e-05)
    list(8.74225e-09 0.885645849 0 1.81389586e-05)
    list(8.74425e-09 0.88564583 0 1.79313446e-05)
    list(8.74625e-09 0.885645812 0 1.78232429e-05)
    list(8.74825e-09 0.885645795 0 1.77597572e-05)
    list(8.75025e-09 0.885645778 0 1.77174271e-05)
    list(8.75225e-09 0.885645761 0 1.76859853e-05)
    list(8.75425e-09 0.885645745 0 1.76607865e-05)
    list(8.75625e-09 0.885645728 0 1.76396173e-05)
    list(8.75825e-09 0.885645712 0 1.76213395e-05)
    list(8.76025e-09 0.885645696 0 1.76053065e-05)
    list(8.76225e-09 0.885645679 0 1.7591109e-05)
    list(8.76425e-09 0.885645663 0 1.75784606e-05)
    list(8.76625e-09 0.885645647 0 1.75671452e-05)
    list(8.76825e-09 0.88564563 0 1.75569905e-05)
    list(8.77025e-09 0.885645614 0 1.75478544e-05)
    list(8.77225e-09 0.885645598 0 1.75396171e-05)
    list(8.77425e-09 0.885645582 0 1.75321762e-05)
    list(8.77625e-09 0.885645565 0 1.75254432e-05)
    list(8.77825e-09 0.885645549 0 1.75193408e-05)
    list(8.78025e-09 0.885645533 0 1.75138016e-05)
    list(8.78225e-09 0.885645517 0 1.75087662e-05)
    list(8.78425e-09 0.8856455 0 1.75041825e-05)
    list(8.78625e-09 0.885645484 0 1.75000041e-05)
    list(8.78825e-09 0.885645468 0 1.74961901e-05)
    list(8.79025e-09 0.885645451 0 1.74927043e-05)
    list(8.79225e-09 0.885645435 0 1.74895143e-05)
    list(8.79425e-09 0.885645419 0 1.74865914e-05)
    list(8.79625e-09 0.885645403 0 1.748391e-05)
    list(8.79825e-09 0.885645386 0 1.74814474e-05)
    list(8.8e-09 0.885645372 0 1.74786457e-05)
    list(8.80075e-09 0.885625476 0.15 2.75683348e-05)
    list(8.80275e-09 0.885562813 0.55 5.31089792e-05)
    list(8.80475e-09 0.885554215 0.95 6.23889801e-05)
    list(8.80535e-09 0.885562862 1 1.80101274e-05)
    list(8.80725e-09 0.8856638 1 2.09628788e-05)
    list(8.80925e-09 0.885794779 1 2.1891615e-05)
    list(8.81125e-09 0.88593311 1 2.17624888e-05)
    list(8.81325e-09 0.886072897 1 2.15602818e-05)
    list(8.81525e-09 0.886212628 1 2.14012856e-05)
    list(8.81725e-09 0.886351898 1 2.12888978e-05)
    list(8.81925e-09 0.886490619 1 2.12087767e-05)
    list(8.82125e-09 0.8866288 1 2.11484765e-05)
    list(8.82325e-09 0.886766473 1 2.10997475e-05)
    list(8.82525e-09 0.886903677 1 2.10575557e-05)
    list(8.82725e-09 0.887040448 1 2.10189307e-05)
    list(8.82925e-09 0.887176819 1 2.09821517e-05)
    list(8.83015e-09 0.88724833 0.97 -1.30512477e-05)
    list(8.83175e-09 0.887488072 0.65 -2.05633701e-05)
    list(8.83375e-09 0.887643923 0.25 -1.62134516e-05)
    list(8.83505e-09 0.887681698 0 2.19679953e-05)
    list(8.83625e-09 0.887681661 0 2.18272192e-05)
    list(8.83825e-09 0.887681623 0 1.95569693e-05)
    list(8.84025e-09 0.887681597 0 1.85633787e-05)
    list(8.84225e-09 0.887681576 0 1.81276619e-05)
    list(8.84425e-09 0.887681557 0 1.79227652e-05)
    list(8.84625e-09 0.887681539 0 1.78168671e-05)
    list(8.84825e-09 0.887681522 0 1.77550678e-05)
    list(8.85025e-09 0.887681505 0 1.77139869e-05)
    list(8.85225e-09 0.887681488 0 1.76834519e-05)
    list(8.85425e-09 0.887681471 0 1.76589025e-05)
    list(8.85625e-09 0.887681455 0 1.76381941e-05)
    list(8.85825e-09 0.887681438 0 1.7620241e-05)
    list(8.86025e-09 0.887681422 0 1.76044357e-05)
    list(8.86225e-09 0.887681405 0 1.75903972e-05)
    list(8.86425e-09 0.887681389 0 1.75778597e-05)
    list(8.86625e-09 0.887681372 0 1.75666213e-05)
    list(8.86825e-09 0.887681356 0 1.75565202e-05)
    list(8.87025e-09 0.887681339 0 1.75474214e-05)
    list(8.87225e-09 0.887681323 0 1.75392104e-05)
    list(8.87425e-09 0.887681307 0 1.75317882e-05)
    list(8.87625e-09 0.88768129 0 1.75250687e-05)
    list(8.87825e-09 0.887681274 0 1.75189764e-05)
    list(8.88025e-09 0.887681257 0 1.7513445e-05)
    list(8.88225e-09 0.887681241 0 1.7508416e-05)
    list(8.88425e-09 0.887681225 0 1.75038377e-05)
    list(8.88625e-09 0.887681208 0 1.74996642e-05)
    list(8.88825e-09 0.887681192 0 1.74958548e-05)
    list(8.89025e-09 0.887681175 0 1.74923734e-05)
    list(8.89225e-09 0.887681159 0 1.74891877e-05)
    list(8.89425e-09 0.887681142 0 1.74862691e-05)
    list(8.89625e-09 0.887681126 0 1.7483592e-05)
    list(8.89825e-09 0.88768111 0 1.74811337e-05)
    list(8.9e-09 0.887681095 0 1.74783375e-05)
    list(8.90075e-09 0.887661073 0.15 2.75729998e-05)
    list(8.90275e-09 0.887597956 0.55 5.28664228e-05)
    list(8.90475e-09 0.887585004 0.95 6.22700602e-05)
    list(8.90535e-09 0.887592235 1 1.7458023e-05)
    list(8.90725e-09 0.887689922 1 2.05616498e-05)
    list(8.90925e-09 0.887818298 1 2.14675412e-05)
    list(8.91125e-09 0.88795436 1 2.13553596e-05)
    list(8.91325e-09 0.888091968 1 2.11608519e-05)
    list(8.91525e-09 0.888229553 1 2.10070374e-05)
    list(8.91725e-09 0.888366692 1 2.08988532e-05)
    list(8.91925e-09 0.888503292 1 2.08223395e-05)
    list(8.92125e-09 0.888639359 1 2.076518e-05)
    list(8.92325e-09 0.888774924 1 2.07191977e-05)
    list(8.92525e-09 0.888910026 1 2.06794153e-05)
    list(8.92725e-09 0.8890447 1 2.06429101e-05)
    list(8.92925e-09 0.889178978 1 2.06080024e-05)
    list(8.93015e-09 0.889249587 0.97 -1.33338364e-05)
    list(8.93175e-09 0.889488925 0.65 -2.06407651e-05)
    list(8.93375e-09 0.889645546 0.25 -1.6240322e-05)
    list(8.93505e-09 0.88968352 0 2.19577691e-05)
    list(8.93625e-09 0.889683483 0 2.18121722e-05)
    list(8.93825e-09 0.889683444 0 1.95407655e-05)
    list(8.94025e-09 0.889683419 0 1.85494273e-05)
    list(8.94225e-09 0.889683398 0 1.81166492e-05)
    list(8.94425e-09 0.889683378 0 1.7914424e-05)
    list(8.94625e-09 0.88968336 0 1.78106815e-05)
    list(8.94825e-09 0.889683343 0 1.77505259e-05)
    list(8.95025e-09 0.889683326 0 1.77106591e-05)
    list(8.95225e-09 0.889683309 0 1.76810034e-05)
    list(8.95425e-09 0.889683292 0 1.76570826e-05)
    list(8.95625e-09 0.889683275 0 1.76368194e-05)
    list(8.95825e-09 0.889683258 0 1.76191794e-05)
    list(8.96025e-09 0.889683242 0 1.76035933e-05)
    list(8.96225e-09 0.889683225 0 1.75897077e-05)
    list(8.96425e-09 0.889683208 0 1.75772764e-05)
    list(8.96625e-09 0.889683192 0 1.75661117e-05)
    list(8.96825e-09 0.889683175 0 1.75560617e-05)
    list(8.97025e-09 0.889683159 0 1.75469984e-05)
    list(8.97225e-09 0.889683142 0 1.75388123e-05)
    list(8.97425e-09 0.889683126 0 1.75314076e-05)
    list(8.97625e-09 0.889683109 0 1.75247007e-05)
    list(8.97825e-09 0.889683092 0 1.75186178e-05)
    list(8.98025e-09 0.889683076 0 1.75130936e-05)
    list(8.98225e-09 0.889683059 0 1.75080706e-05)
    list(8.98425e-09 0.889683043 0 1.75034973e-05)
    list(8.98625e-09 0.889683026 0 1.74993283e-05)
    list(8.98825e-09 0.88968301 0 1.74955231e-05)
    list(8.99025e-09 0.889682993 0 1.74920457e-05)
    list(8.99225e-09 0.889682976 0 1.74888641e-05)
    list(8.99425e-09 0.88968296 0 1.74859495e-05)
    list(8.99625e-09 0.889682943 0 1.74832766e-05)
    list(8.99825e-09 0.889682927 0 1.74808224e-05)
    list(9e-09 0.889682912 0 1.74780313e-05)
    list(9.00075e-09 0.889662766 0.15 2.7577586e-05)
    list(9.00275e-09 0.889599194 0.55 5.26218638e-05)
    list(9.00475e-09 0.889581974 0.95 6.14959324e-05)
    list(9.00535e-09 0.889587803 1 1.69235593e-05)
    list(9.00725e-09 0.889682281 1 2.01752817e-05)
    list(9.00925e-09 0.889808088 1 2.1057599e-05)
    list(9.01125e-09 0.88994191 1 2.09609447e-05)
    list(9.01325e-09 0.890077366 1 2.07729687e-05)
    list(9.01525e-09 0.89021283 1 2.06233418e-05)
    list(9.01725e-09 0.890347864 1 2.05185017e-05)
    list(9.01925e-09 0.890482369 1 2.04448491e-05)
    list(9.02125e-09 0.890616347 1 2.03901812e-05)
    list(9.02325e-09 0.89074983 1 2.03463814e-05)
    list(9.02525e-09 0.890882855 1 2.03085176e-05)
    list(9.02725e-09 0.891015456 1 2.02737058e-05)
    list(9.02925e-09 0.891147666 1 2.02402988e-05)
    list(9.03015e-09 0.891217384 0.97 -1.36137606e-05)
    list(9.03175e-09 0.891456314 0.65 -2.07183753e-05)
    list(9.03375e-09 0.891613692 0.25 -1.62642406e-05)
    list(9.03505e-09 0.89165186 0 2.19367461e-05)
    list(9.03625e-09 0.891651822 0 2.17990407e-05)
    list(9.03825e-09 0.891651784 0 1.95267668e-05)
    list(9.04025e-09 0.891651758 0 1.85378079e-05)
    list(9.04225e-09 0.891651737 0 1.81079984e-05)
    list(9.04425e-09 0.891651717 0 1.7908432e-05)
    list(9.04625e-09 0.891651699 0 1.78068172e-05)
    list(9.04825e-09 0.891651681 0 1.77482749e-05)
    list(9.05025e-09 0.891651664 0 1.77095941e-05)
    list(9.05225e-09 0.891651647 0 1.76807934e-05)
    list(9.05425e-09 0.89165163 0 1.76574802e-05)
    list(9.05625e-09 0.891651613 0 1.76376442e-05)
    list(9.05825e-09 0.891651596 0 1.76203018e-05)
    list(9.06025e-09 0.891651579 0 1.76049208e-05)
    list(9.06225e-09 0.891651563 0 1.75911748e-05)
    list(9.06425e-09 0.891651546 0 1.75788373e-05)
    list(9.06625e-09 0.891651529 0 1.75677343e-05)
    list(9.06825e-09 0.891651512 0 1.75577236e-05)
    list(9.07025e-09 0.891651496 0 1.75486843e-05)
    list(9.07225e-09 0.891651479 0 1.75405114e-05)
    list(9.07425e-09 0.891651462 0 1.75331128e-05)
    list(9.07625e-09 0.891651445 0 1.7526407e-05)
    list(9.07825e-09 0.891651429 0 1.7520322e-05)
    list(9.08025e-09 0.891651412 0 1.75147937e-05)
    list(9.08225e-09 0.891651395 0 1.7509765e-05)
    list(9.08425e-09 0.891651379 0 1.75051854e-05)
    list(9.08625e-09 0.891651362 0 1.75010097e-05)
    list(9.08825e-09 0.891651345 0 1.74971975e-05)
    list(9.09025e-09 0.891651328 0 1.74937132e-05)
    list(9.09225e-09 0.891651312 0 1.74905245e-05)
    list(9.09425e-09 0.891651295 0 1.74876032e-05)
    list(9.09625e-09 0.891651278 0 1.74849235e-05)
    list(9.09825e-09 0.891651261 0 1.74824628e-05)
    list(9.1e-09 0.891651247 0 1.74796638e-05)
    list(9.10075e-09 0.891630979 0.15 2.7582088e-05)
    list(9.10275e-09 0.89156695 0.55 5.23753773e-05)
    list(9.10475e-09 0.89154553 0.95 6.03091071e-05)
    list(9.10535e-09 0.891549969 1 1.64021063e-05)
    list(9.10725e-09 0.891641274 1 1.97996698e-05)
    list(9.10925e-09 0.891764543 1 2.06582591e-05)
    list(9.11125e-09 0.891896153 1 2.05762058e-05)
    list(9.11325e-09 0.892029484 1 2.0394007e-05)
    list(9.11525e-09 0.892162853 1 2.02479277e-05)
    list(9.11725e-09 0.892295807 1 2.01458789e-05)
    list(9.11925e-09 0.892428242 1 2.0074607e-05)
    list(9.12125e-09 0.892560158 1 2.00220128e-05)
    list(9.12325e-09 0.892691584 1 1.99800318e-05)
    list(9.12525e-09 0.892822557 1 1.99437705e-05)
    list(9.12725e-09 0.892953111 1 1.99103771e-05)
    list(9.12925e-09 0.893083277 1 1.98782319e-05)
    list(9.13015e-09 0.893152115 0.97 -1.38909456e-05)
    list(9.13175e-09 0.893390631 0.65 -2.07961119e-05)
    list(9.13375e-09 0.893548752 0.25 -1.6285163e-05)
    list(9.13505e-09 0.893587111 0 2.19310464e-05)
    list(9.13625e-09 0.893587073 0 2.17890261e-05)
    list(9.13825e-09 0.893587034 0 1.95161189e-05)
    list(9.14025e-09 0.893587009 0 1.85296947e-05)
    list(9.14225e-09 0.893586987 0 1.81029013e-05)
    list(9.14425e-09 0.893586968 0 1.79059936e-05)
    list(9.14625e-09 0.893586949 0 1.78064894e-05)
    list(9.14825e-09 0.893586931 0 1.77495388e-05)
    list(9.15025e-09 0.893586914 0 1.77120235e-05)
    list(9.15225e-09 0.893586897 0 1.76840596e-05)
    list(9.15425e-09 0.893586879 0 1.76613386e-05)
    list(9.15625e-09 0.893586862 0 1.76419163e-05)
    list(9.15825e-09 0.893586845 0 1.76248591e-05)
    list(9.16025e-09 0.893586828 0 1.76096716e-05)
    list(9.16225e-09 0.893586811 0 1.75960543e-05)
    list(9.16425e-09 0.893586795 0 1.75837995e-05)
    list(9.16625e-09 0.893586778 0 1.75727471e-05)
    list(9.16825e-09 0.893586761 0 1.75627644e-05)
    list(9.17025e-09 0.893586744 0 1.75537374e-05)
    list(9.17225e-09 0.893586727 0 1.7545566e-05)
    list(9.17425e-09 0.89358671 0 1.75381614e-05)
    list(9.17625e-09 0.893586693 0 1.75314446e-05)
    list(9.17825e-09 0.893586676 0 1.75253451e-05)
    list(9.18025e-09 0.893586659 0 1.75198e-05)
    list(9.18225e-09 0.893586643 0 1.75147533e-05)
    list(9.18425e-09 0.893586626 0 1.75101547e-05)
    list(9.18625e-09 0.893586609 0 1.75059595e-05)
    list(9.18825e-09 0.893586592 0 1.75021278e-05)
    list(9.19025e-09 0.893586575 0 1.74986238e-05)
    list(9.19225e-09 0.893586558 0 1.74954157e-05)
    list(9.19425e-09 0.893586541 0 1.7492475e-05)
    list(9.19625e-09 0.893586524 0 1.74897763e-05)
    list(9.19825e-09 0.893586508 0 1.74872969e-05)
    list(9.2e-09 0.893586493 0 1.74844748e-05)
    list(9.20075e-09 0.893566105 0.15 2.75865057e-05)
    list(9.20275e-09 0.893501619 0.55 5.21270447e-05)
    list(9.20475e-09 0.893476043 0.95 5.91432734e-05)
    list(9.20535e-09 0.893479116 1 1.58891926e-05)
    list(9.20725e-09 0.8935673 1 1.94294504e-05)
    list(9.20925e-09 0.89368807 1 2.03297723e-05)
    list(9.21125e-09 0.893817496 1 2.02593879e-05)
    list(9.21325e-09 0.893948727 1 2.00803857e-05)
    list(9.21525e-09 0.894080028 1 1.99356061e-05)
    list(9.21725e-09 0.894210928 1 1.98343919e-05)
    list(9.21925e-09 0.894341319 1 1.97637972e-05)
    list(9.22125e-09 0.894471197 1 1.97117939e-05)
    list(9.22325e-09 0.894600591 1 1.96703408e-05)
    list(9.22525e-09 0.894729537 1 1.96345583e-05)
    list(9.22725e-09 0.894858069 1 1.96016049e-05)
    list(9.22925e-09 0.894986217 1 1.95698692e-05)
    list(9.23015e-09 0.895054185 0.97 -1.41656166e-05)
    list(9.23175e-09 0.89529228 0.65 -2.08742505e-05)
    list(9.23375e-09 0.895451129 0.25 -1.63033869e-05)
    list(9.23505e-09 0.895489676 0 2.19253194e-05)
    list(9.23625e-09 0.895489638 0 2.17614013e-05)
    list(9.23825e-09 0.895489599 0 1.94876008e-05)
    list(9.24025e-09 0.895489573 0 1.85037643e-05)
    list(9.24225e-09 0.895489551 0 1.80799337e-05)
    list(9.24425e-09 0.895489531 0 1.78856038e-05)
    list(9.24625e-09 0.895489513 0 1.77881349e-05)
    list(9.24825e-09 0.895489495 0 1.77327195e-05)
    list(9.25025e-09 0.895489477 0 1.76963345e-05)
    list(9.25225e-09 0.89548946 0 1.76691925e-05)
    list(9.25425e-09 0.895489442 0 1.76470665e-05)
    list(9.25625e-09 0.895489425 0 1.76280758e-05)
    list(9.25825e-09 0.895489408 0 1.76113341e-05)
    list(9.26025e-09 0.895489391 0 1.75963807e-05)
    list(9.26225e-09 0.895489374 0 1.75829406e-05)
    list(9.26425e-09 0.895489357 0 1.75708237e-05)
    list(9.26625e-09 0.89548934 0 1.75598823e-05)
    list(9.26825e-09 0.895489323 0 1.75499922e-05)
    list(9.27025e-09 0.895489306 0 1.75410455e-05)
    list(9.27225e-09 0.895489289 0 1.75329459e-05)
    list(9.27425e-09 0.895489272 0 1.75256075e-05)
    list(9.27625e-09 0.895489254 0 1.75189533e-05)
    list(9.27825e-09 0.895489237 0 1.75129139e-05)
    list(9.28025e-09 0.89548922 0 1.75074274e-05)
    list(9.28225e-09 0.895489203 0 1.75024381e-05)
    list(9.28425e-09 0.895489186 0 1.74978961e-05)
    list(9.28625e-09 0.895489169 0 1.7493757e-05)
    list(9.28825e-09 0.895489152 0 1.74899808e-05)
    list(9.29025e-09 0.895489135 0 1.74865319e-05)
    list(9.29225e-09 0.895489118 0 1.74833785e-05)
    list(9.29425e-09 0.895489101 0 1.74804921e-05)
    list(9.29625e-09 0.895489084 0 1.74778472e-05)
    list(9.29825e-09 0.895489067 0 1.7475421e-05)
    list(9.3e-09 0.895489052 0 1.74726647e-05)
    list(9.30075e-09 0.895468547 0.15 2.75908895e-05)
    list(9.30275e-09 0.895403602 0.55 5.18769933e-05)
    list(9.30475e-09 0.895373916 0.95 5.79987646e-05)
    list(9.30535e-09 0.895375648 1 1.53847019e-05)
    list(9.30725e-09 0.895460762 1 1.90645667e-05)
    list(9.30925e-09 0.895579072 1 2.00690581e-05)
    list(9.31125e-09 0.89570634 1 2.00075169e-05)
    list(9.31325e-09 0.895835499 1 1.98292436e-05)
    list(9.31525e-09 0.895964758 1 1.96836175e-05)
    list(9.31725e-09 0.89609363 1 1.95813706e-05)
    list(9.31925e-09 0.896222001 1 1.95098281e-05)
    list(9.32125e-09 0.896349867 1 1.94570014e-05)
    list(9.32325e-09 0.896477255 1 1.94148455e-05)
    list(9.32525e-09 0.8966042 1 1.93784705e-05)
    list(9.32725e-09 0.896730734 1 1.93450248e-05)
    list(9.32925e-09 0.896856889 1 1.93128869e-05)
    list(9.33015e-09 0.896923999 0.97 -1.44377334e-05)
    list(9.33175e-09 0.897161671 0.65 -2.09525124e-05)
    list(9.33375e-09 0.897321236 0.25 -1.63189884e-05)
    list(9.33505e-09 0.897359967 0 2.19195987e-05)
    list(9.33625e-09 0.897359929 0 2.17408585e-05)
    list(9.33825e-09 0.89735989 0 1.94814852e-05)
    list(9.34025e-09 0.897359863 0 1.85005898e-05)
    list(9.34225e-09 0.897359842 0 1.80798798e-05)
    list(9.34425e-09 0.897359822 0 1.78881874e-05)
    list(9.34625e-09 0.897359803 0 1.7792765e-05)
    list(9.34825e-09 0.897359785 0 1.77388696e-05)
    list(9.35025e-09 0.897359767 0 1.77035839e-05)
    list(9.35225e-09 0.897359749 0 1.76772219e-05)
    list(9.35425e-09 0.897359732 0 1.76556405e-05)
    list(9.35625e-09 0.897359715 0 1.76370237e-05)
    list(9.35825e-09 0.897359697 0 1.76205336e-05)
    list(9.36025e-09 0.89735968 0 1.76057449e-05)
    list(9.36225e-09 0.897359663 0 1.7592408e-05)
    list(9.36425e-09 0.897359646 0 1.75803512e-05)
    list(9.36625e-09 0.897359628 0 1.75694394e-05)
    list(9.36825e-09 0.897359611 0 1.75595578e-05)
    list(9.37025e-09 0.897359594 0 1.75506049e-05)
    list(9.37225e-09 0.897359577 0 1.75424891e-05)
    list(9.37425e-09 0.89735956 0 1.75351276e-05)
    list(9.37625e-09 0.897359542 0 1.75284457e-05)
    list(9.37825e-09 0.897359525 0 1.75223757e-05)
    list(9.38025e-09 0.897359508 0 1.75168566e-05)
    list(9.38225e-09 0.897359491 0 1.75118337e-05)
    list(9.38425e-09 0.897359474 0 1.75072575e-05)
    list(9.38625e-09 0.897359456 0 1.75030839e-05)
    list(9.38825e-09 0.897359439 0 1.74992734e-05)
    list(9.39025e-09 0.897359422 0 1.74957904e-05)
    list(9.39225e-09 0.897359405 0 1.74926032e-05)
    list(9.39425e-09 0.897359388 0 1.74896835e-05)
    list(9.39625e-09 0.89735937 0 1.74870057e-05)
    list(9.39825e-09 0.897359353 0 1.74845472e-05)
    list(9.4e-09 0.897359338 0 1.7481751e-05)
    list(9.40075e-09 0.897338717 0.15 2.75951474e-05)
    list(9.40275e-09 0.897273312 0.55 5.16252044e-05)
    list(9.40475e-09 0.897239563 0.95 5.68756998e-05)
    list(9.40535e-09 0.897239977 1 1.48885518e-05)
    list(9.40725e-09 0.897322069 1 1.87048399e-05)
    list(9.40925e-09 0.897437955 1 1.98111068e-05)
    list(9.41125e-09 0.897563095 1 1.97582023e-05)
    list(9.41325e-09 0.897690209 1 1.9580629e-05)
    list(9.41525e-09 0.897817451 1 1.94341742e-05)
    list(9.41725e-09 0.897944321 1 1.93309221e-05)
    list(9.41925e-09 0.898070699 1 1.92584594e-05)
    list(9.42125e-09 0.898196578 1 1.92048349e-05)
    list(9.42325e-09 0.898321985 1 1.91619992e-05)
    list(9.42525e-09 0.898446953 1 1.91250524e-05)
    list(9.42725e-09 0.898571516 1 1.90911326e-05)
    list(9.42925e-09 0.898695703 1 1.9058609e-05)
    list(9.43015e-09 0.898761964 0.97 -1.47069368e-05)
    list(9.43175e-09 0.898999212 0.65 -2.1030687e-05)
    list(9.43375e-09 0.899159479 0.25 -1.63318396e-05)
    list(9.43505e-09 0.89919839 0 2.19137766e-05)
    list(9.43625e-09 0.899198352 0 2.17293581e-05)
    list(9.43825e-09 0.899198312 0 1.94534211e-05)
    list(9.44025e-09 0.899198286 0 1.84756196e-05)
    list(9.44225e-09 0.899198264 0 1.80580164e-05)
    list(9.44425e-09 0.899198244 0 1.78688897e-05)
    list(9.44625e-09 0.899198225 0 1.77754373e-05)
    list(9.44825e-09 0.899198207 0 1.77230006e-05)
    list(9.45025e-09 0.899198189 0 1.76887737e-05)
    list(9.45225e-09 0.899198171 0 1.76631724e-05)
    list(9.45425e-09 0.899198153 0 1.76421352e-05)
    list(9.45625e-09 0.899198136 0 1.76239081e-05)
    list(9.45825e-09 0.899198118 0 1.76076991e-05)
    list(9.46025e-09 0.899198101 0 1.75931157e-05)
    list(9.46225e-09 0.899198083 0 1.75799317e-05)
    list(9.46425e-09 0.899198066 0 1.75679919e-05)
    list(9.46625e-09 0.899198049 0 1.75571728e-05)
    list(9.46825e-09 0.899198031 0 1.75473676e-05)
    list(9.47025e-09 0.899198014 0 1.75384801e-05)
    list(9.47225e-09 0.899197997 0 1.75304227e-05)
    list(9.47425e-09 0.899197979 0 1.7523115e-05)
    list(9.47625e-09 0.899197962 0 1.7516484e-05)
    list(9.47825e-09 0.899197945 0 1.75104632e-05)
    list(9.48025e-09 0.899197927 0 1.75049922e-05)
    list(9.48225e-09 0.89919791 0 1.75000168e-05)
    list(9.48425e-09 0.899197892 0 1.74954878e-05)
    list(9.48625e-09 0.899197875 0 1.74913612e-05)
    list(9.48825e-09 0.899197858 0 1.74875974e-05)
    list(9.49025e-09 0.89919784 0 1.74841611e-05)
    list(9.49225e-09 0.899197823 0 1.74810204e-05)
    list(9.49425e-09 0.899197806 0 1.7478147e-05)
    list(9.49625e-09 0.899197788 0 1.74755153e-05)
    list(9.49825e-09 0.899197771 0 1.74731026e-05)
    list(9.5e-09 0.899197756 0 1.74703632e-05)
    list(9.50075e-09 0.899177021 0.15 2.75993771e-05)
    list(9.50275e-09 0.899111155 0.55 5.1371845e-05)
    list(9.50475e-09 0.89907339 0.95 5.57743208e-05)
    list(9.50535e-09 0.899072509 1 1.4400608e-05)
    list(9.50725e-09 0.899151631 1 1.83504874e-05)
    list(9.50925e-09 0.89926513 1 1.95557561e-05)
    list(9.51125e-09 0.899388171 1 1.95112551e-05)
    list(9.51325e-09 0.899513267 1 1.93343633e-05)
    list(9.51525e-09 0.899638519 1 1.91871113e-05)
    list(9.51725e-09 0.899763412 1 1.90828926e-05)
    list(9.51925e-09 0.899887822 1 1.90095455e-05)
    list(9.52125e-09 0.900011739 1 1.89551546e-05)
    list(9.52325e-09 0.90013519 1 1.89116667e-05)
    list(9.52525e-09 0.900258207 1 1.88741722e-05)
    list(9.52725e-09 0.900380823 1 1.88397997e-05)
    list(9.52925e-09 0.900503068 1 1.88069089e-05)
    list(9.53015e-09 0.90056849 0.97 -1.49732076e-05)
    list(9.53175e-09 0.90080531 0.65 -2.11087361e-05)
    list(9.53375e-09 0.900966266 0.25 -1.63420709e-05)
    list(9.53505e-09 0.901005355 0 2.19078555e-05)
    list(9.53625e-09 0.901005316 0 2.17178511e-05)
    list(9.53825e-09 0.901005276 0 1.94503601e-05)
    list(9.54025e-09 0.90100525 0 1.84760201e-05)
    list(9.54225e-09 0.901005228 0 1.80617567e-05)
    list(9.54425e-09 0.901005207 0 1.78753085e-05)
    list(9.54625e-09 0.901005188 0 1.77838786e-05)
    list(9.54825e-09 0.90100517 0 1.77329201e-05)
    list(9.55025e-09 0.901005152 0 1.76997507e-05)
    list(9.55225e-09 0.901005134 0 1.76748935e-05)
    list(9.55425e-09 0.901005116 0 1.76543716e-05)
    list(9.55625e-09 0.901005098 0 1.76364951e-05)
    list(9.55825e-09 0.901005081 0 1.7620519e-05)
    list(9.56025e-09 0.901005063 0 1.76060847e-05)
    list(9.56225e-09 0.901005046 0 1.75929908e-05)
    list(9.56425e-09 0.901005028 0 1.75810992e-05)
    list(9.56625e-09 0.901005011 0 1.75702989e-05)
    list(9.56825e-09 0.901004993 0 1.7560492e-05)
    list(9.57025e-09 0.901004975 0 1.75515885e-05)
    list(9.57225e-09 0.901004958 0 1.75435051e-05)
    list(9.57425e-09 0.90100494 0 1.75361648e-05)
    list(9.57625e-09 0.901004923 0 1.75294965e-05)
    list(9.57825e-09 0.901004905 0 1.75234354e-05)
    list(9.58025e-09 0.901004888 0 1.75179222e-05)
    list(9.58225e-09 0.90100487 0 1.75129034e-05)
    list(9.58425e-09 0.901004853 0 1.75083305e-05)
    list(9.58625e-09 0.901004835 0 1.75041598e-05)
    list(9.58825e-09 0.901004818 0 1.7500352e-05)
    list(9.59025e-09 0.9010048 0 1.74968719e-05)
    list(9.59225e-09 0.901004783 0 1.74936879e-05)
    list(9.59425e-09 0.901004765 0 1.74907715e-05)
    list(9.59625e-09 0.901004748 0 1.74880974e-05)
    list(9.59825e-09 0.90100473 0 1.74856429e-05)
    list(9.6e-09 0.901004715 0 1.74828519e-05)
    list(9.60075e-09 0.900983869 0.15 2.76034809e-05)
    list(9.60275e-09 0.90091754 0.55 5.11168845e-05)
    list(9.60475e-09 0.900875806 0.95 5.46946027e-05)
    list(9.60535e-09 0.900873653 1 1.39207894e-05)
    list(9.60725e-09 0.900949855 1 1.80013402e-05)
    list(9.60925e-09 0.901061003 1 1.93030347e-05)
    list(9.61125e-09 0.901181975 1 1.92666892e-05)
    list(9.61325e-09 0.901305079 1 1.90904548e-05)
    list(9.61525e-09 0.901428367 1 1.89424344e-05)
    list(9.61725e-09 0.901551309 1 1.88372864e-05)
    list(9.61925e-09 0.901673776 1 1.87630904e-05)
    list(9.62125e-09 0.901795758 1 1.87079648e-05)
    list(9.62325e-09 0.901917278 1 1.86638526e-05)
    list(9.62525e-09 0.902038369 1 1.86258351e-05)
    list(9.62725e-09 0.902159063 1 1.85910315e-05)
    list(9.62925e-09 0.90227939 1 1.85577926e-05)
    list(9.63015e-09 0.902343985 0.97 -1.52365272e-05)
    list(9.63175e-09 0.902580374 0.65 -2.11866228e-05)
    list(9.63375e-09 0.902742006 0.25 -1.63498156e-05)
    list(9.63505e-09 0.902781268 0 2.19018424e-05)
    list(9.63625e-09 0.902781229 0 2.17063455e-05)
    list(9.63825e-09 0.902781189 0 1.94207723e-05)
    list(9.64025e-09 0.902781162 0 1.84571127e-05)
    list(9.64225e-09 0.90278114 0 1.80462912e-05)
    list(9.64425e-09 0.90278112 0 1.78625042e-05)
    list(9.64625e-09 0.902781101 0 1.77730447e-05)
    list(9.64825e-09 0.902781082 0 1.77235132e-05)
    list(9.65025e-09 0.902781064 0 1.76913639e-05)
    list(9.65225e-09 0.902781046 0 1.76672302e-05)
    list(9.65425e-09 0.902781028 0 1.76472193e-05)
    list(9.65625e-09 0.90278101 0 1.76297033e-05)
    list(9.65825e-09 0.902780992 0 1.7613982e-05)
    list(9.66025e-09 0.902780974 0 1.75997287e-05)
    list(9.66225e-09 0.902780957 0 1.75867647e-05)
    list(9.66425e-09 0.902780939 0 1.75749679e-05)
    list(9.66625e-09 0.902780921 0 1.75642384e-05)
    list(9.66825e-09 0.902780904 0 1.7554486e-05)
    list(9.67025e-09 0.902780886 0 1.75456261e-05)
    list(9.67225e-09 0.902780868 0 1.7537579e-05)
    list(9.67425e-09 0.902780851 0 1.75302703e-05)
    list(9.67625e-09 0.902780833 0 1.75236306e-05)
    list(9.67825e-09 0.902780815 0 1.75175961e-05)
    list(9.68025e-09 0.902780798 0 1.75121085e-05)
    list(9.68225e-09 0.90278078 0 1.75071147e-05)
    list(9.68425e-09 0.902780762 0 1.75025664e-05)
    list(9.68625e-09 0.902780745 0 1.74984201e-05)
    list(9.68825e-09 0.902780727 0 1.74946367e-05)
    list(9.69025e-09 0.902780709 0 1.7491181e-05)
    list(9.69225e-09 0.902780691 0 1.74880213e-05)
    list(9.69425e-09 0.902780674 0 1.74851292e-05)
    list(9.69625e-09 0.902780656 0 1.74824795e-05)
    list(9.69825e-09 0.902780638 0 1.74800492e-05)
    list(9.7e-09 0.902780623 0 1.74772884e-05)
    list(9.70075e-09 0.902759668 0.15 2.76075511e-05)
    list(9.70275e-09 0.902692874 0.55 5.08604773e-05)
    list(9.70475e-09 0.902647219 0.95 5.36366386e-05)
    list(9.70535e-09 0.902643819 1 1.3449346e-05)
    list(9.70725e-09 0.902717149 1 1.7657346e-05)
    list(9.70925e-09 0.902825982 1 1.90531038e-05)
    list(9.71125e-09 0.902944912 1 1.90247462e-05)
    list(9.71325e-09 0.903066051 1 1.88491575e-05)
    list(9.71525e-09 0.903187401 1 1.87003947e-05)
    list(9.71725e-09 0.903308417 1 1.8594349e-05)
    list(9.71925e-09 0.903428967 1 1.85193337e-05)
    list(9.72125e-09 0.903549038 1 1.84634999e-05)
    list(9.72325e-09 0.903668653 1 1.84187868e-05)
    list(9.72525e-09 0.903787844 1 1.83802669e-05)
    list(9.72725e-09 0.903906641 1 1.83450504e-05)
    list(9.72925e-09 0.904025075 1 1.83114794e-05)
    list(9.73015e-09 0.904088854 0.97 -1.54968804e-05)
    list(9.73175e-09 0.90432481 0.65 -2.12643138e-05)
    list(9.73375e-09 0.904487103 0.25 -1.63552161e-05)
    list(9.73505e-09 0.904526536 0 2.18957458e-05)
    list(9.73625e-09 0.904526497 0 2.16948505e-05)
    list(9.73825e-09 0.904526457 0 1.94065342e-05)
    list(9.74025e-09 0.90452643 0 1.84412948e-05)
    list(9.74225e-09 0.904526408 0 1.80341207e-05)
    list(9.74425e-09 0.904526387 0 1.78530793e-05)
    list(9.74625e-09 0.904526368 0 1.77656024e-05)
    list(9.74825e-09 0.904526349 0 1.77174842e-05)
    list(9.75025e-09 0.904526331 0 1.7686334e-05)
    list(9.75225e-09 0.904526312 0 1.76629021e-05)
    list(9.75425e-09 0.904526294 0 1.76433821e-05)
    list(9.75625e-09 0.904526276 0 1.76262084e-05)
    list(9.75825e-09 0.904526258 0 1.76107252e-05)
    list(9.76025e-09 0.90452624 0 1.75966376e-05)
    list(9.76225e-09 0.904526222 0 1.75837889e-05)
    list(9.76425e-09 0.904526205 0 1.75720728e-05)
    list(9.76625e-09 0.904526187 0 1.75614003e-05)
    list(9.76825e-09 0.904526169 0 1.75516887e-05)
    list(9.77025e-09 0.904526151 0 1.75428588e-05)
    list(9.77225e-09 0.904526133 0 1.75348347e-05)
    list(9.77425e-09 0.904526115 0 1.75275441e-05)
    list(9.77625e-09 0.904526097 0 1.75209196e-05)
    list(9.77825e-09 0.90452608 0 1.75148985e-05)
    list(9.78025e-09 0.904526062 0 1.75094232e-05)
    list(9.78225e-09 0.904526044 0 1.7504441e-05)
    list(9.78425e-09 0.904526026 0 1.74999041e-05)
    list(9.78625e-09 0.904526008 0 1.74957692e-05)
    list(9.78825e-09 0.90452599 0 1.74919972e-05)
    list(9.79025e-09 0.904525973 0 1.74885529e-05)
    list(9.79225e-09 0.904525955 0 1.74854049e-05)
    list(9.79425e-09 0.904525937 0 1.74825246e-05)
    list(9.79625e-09 0.904525919 0 1.74798866e-05)
    list(9.79825e-09 0.904525901 0 1.74774683e-05)
    list(9.8e-09 0.904525886 0 1.74747224e-05)
    list(9.80075e-09 0.904504823 0.15 2.76116241e-05)
    list(9.80275e-09 0.904437563 0.55 5.0602719e-05)
    list(9.80475e-09 0.904388037 0.95 5.26003963e-05)
    list(9.80535e-09 0.90438341 1 1.2985485e-05)
    list(9.80725e-09 0.904453916 1 1.73184793e-05)
    list(9.80925e-09 0.904560469 1 1.88059527e-05)
    list(9.81125e-09 0.904677388 1 1.87853824e-05)
    list(9.81325e-09 0.904796588 1 1.86104205e-05)
    list(9.81525e-09 0.904916025 1 1.84609397e-05)
    list(9.81725e-09 0.905035142 1 1.83540278e-05)
    list(9.81925e-09 0.9051538 1 1.82782233e-05)
    list(9.82125e-09 0.905271986 1 1.82217081e-05)
    list(9.82325e-09 0.90538972 1 1.81764178e-05)
    list(9.82525e-09 0.905507035 1 1.81374165e-05)
    list(9.82725e-09 0.905623961 1 1.81018055e-05)
    list(9.82925e-09 0.905740527 1 1.80679187e-05)
    list(9.83015e-09 0.9058035 0.97 -1.57542523e-05)
    list(9.83175e-09 0.90603902 0.65 -2.13417769e-05)
    list(9.83375e-09 0.906201964 0.25 -1.63584208e-05)
    list(9.83505e-09 0.906241564 0 2.18894187e-05)
    list(9.83625e-09 0.906241524 0 2.16832461e-05)
    list(9.83825e-09 0.906241484 0 1.93924142e-05)
    list(9.84025e-09 0.906241457 0 1.84254827e-05)
    list(9.84225e-09 0.906241434 0 1.80260236e-05)
    list(9.84425e-09 0.906241414 0 1.78479237e-05)
    list(9.84625e-09 0.906241394 0 1.77625047e-05)
    list(9.84825e-09 0.906241375 0 1.77158246e-05)
    list(9.85025e-09 0.906241357 0 1.76856784e-05)
    list(9.85225e-09 0.906241338 0 1.76629458e-05)
    list(9.85425e-09 0.90624132 0 1.76439115e-05)
    list(9.85625e-09 0.906241302 0 1.76270737e-05)
    list(9.85825e-09 0.906241284 0 1.76118217e-05)
    list(9.86025e-09 0.906241265 0 1.75978921e-05)
    list(9.86225e-09 0.906241247 0 1.75851505e-05)
    list(9.86425e-09 0.906241229 0 1.75735062e-05)
    list(9.86625e-09 0.906241211 0 1.75628812e-05)
    list(9.86825e-09 0.906241193 0 1.75532003e-05)
    list(9.87025e-09 0.906241175 0 1.75443896e-05)
    list(9.87225e-09 0.906241157 0 1.75363769e-05)
    list(9.87425e-09 0.906241139 0 1.75290927e-05)
    list(9.87625e-09 0.906241121 0 1.75224711e-05)
    list(9.87825e-09 0.906241103 0 1.75164508e-05)
    list(9.88025e-09 0.906241085 0 1.75109749e-05)
    list(9.88225e-09 0.906241067 0 1.75059913e-05)
    list(9.88425e-09 0.906241049 0 1.75014526e-05)
    list(9.88625e-09 0.906241031 0 1.74973157e-05)
    list(9.88825e-09 0.906241013 0 1.74935418e-05)
    list(9.89025e-09 0.906240995 0 1.74900956e-05)
    list(9.89225e-09 0.906240977 0 1.74869457e-05)
    list(9.89425e-09 0.906240959 0 1.74840638e-05)
    list(9.89625e-09 0.906240941 0 1.74814244e-05)
    list(9.89825e-09 0.906240923 0 1.74790048e-05)
    list(9.9e-09 0.906240908 0 1.74762574e-05)
    list(9.90075e-09 0.90621974 0.15 2.76153864e-05)
    list(9.90275e-09 0.906152011 0.55 5.03433575e-05)
    list(9.90475e-09 0.906098663 0.95 5.15854366e-05)
    list(9.90535e-09 0.906092832 1 1.25294587e-05)
    list(9.90725e-09 0.906160563 1 1.69846898e-05)
    list(9.90925e-09 0.90626487 1 1.85615757e-05)
    list(9.91125e-09 0.906379805 1 1.85485992e-05)
    list(9.91325e-09 0.906497094 1 1.83742493e-05)
    list(9.91525e-09 0.906614644 1 1.82240774e-05)
    list(9.91725e-09 0.906731887 1 1.81163324e-05)
    list(9.91925e-09 0.906848679 1 1.80397696e-05)
    list(9.92125e-09 0.906965004 1 1.79826006e-05)
    list(9.92325e-09 0.907080883 1 1.79367575e-05)
    list(9.92525e-09 0.907196347 1 1.78972961e-05)
    list(9.92725e-09 0.907311427 1 1.78613093e-05)
    list(9.92925e-09 0.90742615 1 1.78271232e-05)
    list(9.93015e-09 0.907488327 0.97 -1.60086299e-05)
    list(9.93175e-09 0.90772341 0.65 -2.14189823e-05)
    list(9.93375e-09 0.90788699 0.25 -1.63595818e-05)
    list(9.93505e-09 0.907926754 0 2.18830018e-05)
    list(9.93625e-09 0.907926715 0 2.16716555e-05)
    list(9.93825e-09 0.907926674 0 1.93784681e-05)
    list(9.94025e-09 0.907926647 0 1.84131194e-05)
    list(9.94225e-09 0.907926624 0 1.80135603e-05)
    list(9.94425e-09 0.907926603 0 1.78385207e-05)
    list(9.94625e-09 0.907926584 0 1.77552409e-05)
    list(9.94825e-09 0.907926565 0 1.77100079e-05)
    list(9.95025e-09 0.907926546 0 1.76808507e-05)
    list(9.95225e-09 0.907926527 0 1.76587981e-05)
    list(9.95425e-09 0.907926509 0 1.76402327e-05)
    list(9.95625e-09 0.90792649 0 1.76237185e-05)
    list(9.95825e-09 0.907926472 0 1.76086899e-05)
    list(9.96025e-09 0.907926454 0 1.75949148e-05)
    list(9.96225e-09 0.907926436 0 1.75822801e-05)
    list(9.96425e-09 0.907926417 0 1.75707101e-05)
    list(9.96625e-09 0.907926399 0 1.75601372e-05)
    list(9.96825e-09 0.907926381 0 1.75504934e-05)
    list(9.97025e-09 0.907926363 0 1.75417097e-05)
    list(9.97225e-09 0.907926345 0 1.75337174e-05)
    list(9.97425e-09 0.907926327 0 1.75264492e-05)
    list(9.97625e-09 0.907926308 0 1.75198409e-05)
    list(9.97825e-09 0.90792629 0 1.75138322e-05)
    list(9.98025e-09 0.907926272 0 1.75083671e-05)
    list(9.98225e-09 0.907926254 0 1.75033937e-05)
    list(9.98425e-09 0.907926236 0 1.74988651e-05)
    list(9.98625e-09 0.907926218 0 1.74947382e-05)
    list(9.98825e-09 0.907926199 0 1.74909743e-05)
    list(9.99025e-09 0.907926181 0 1.74875384e-05)
    list(9.99225e-09 0.907926163 0 1.74843989e-05)
    list(9.99425e-09 0.907926145 0 1.74815275e-05)
    list(9.99625e-09 0.907926127 0 1.74788988e-05)
    list(9.99825e-09 0.907926108 0 1.74764899e-05)
    list(1e-08 0.907926093 0 1.7473756e-05)
  )
  n = length(rows)
  x = drCreateVec('double n)
  y = drCreateVec('double n)
  ctl = drCreateVec('double n)
  watts = drCreateVec('double n)
  k = 0
  foreach(row rows
    drSetElem(x k car(row))
    drSetElem(y k cadr(row))
    drSetElem(ctl k caddr(row))
    drSetElem(watts k cadddr(row))
    k = k + 1
  )
  printf("charging: %d measured points plotted (display decimated 4:1)\n" n)
  plot(drCreateWaveform(x y) ?expr list("ngspice imported: charging Vop (V)"))
  plot(drCreateWaveform(x ctl) ?expr list("ngspice imported: charging control (V)"))
  plot(drCreateWaveform(x watts) ?expr list("ngspice imported: charging VDD power (W)"))
  ; discharging: time in seconds, Vop in volts, active control in volts, VDD power in watts
  rows = list(
    list(0 0.62 0 1.75085724e-05)
    list(4e-14 0.620002842 0.008 1.39945589e-05)
    list(6.4e-13 0.62004779 0.128 9.02716477e-06)
    list(2.64e-12 0.620093052 0.528 1.02753014e-05)
    list(4.64e-12 0.619096331 0.928 2.52809513e-06)
    list(5.35e-12 0.618364916 1 1.13533803e-05)
    list(7.25e-12 0.61648132 1 1.08535315e-05)
    list(9.25e-12 0.614719612 1 1.04134595e-05)
    list(1.125e-11 0.613032235 1 1.00398404e-05)
    list(1.325e-11 0.611370424 1 9.69971479e-06)
    list(1.525e-11 0.609718403 1 9.37594001e-06)
    list(1.725e-11 0.608070879 1 9.05890947e-06)
    list(1.925e-11 0.606426046 1 8.7403112e-06)
    list(2.125e-11 0.60478328 1 8.40784079e-06)
    list(2.325e-11 0.603142368 1 8.03687066e-06)
    list(2.525e-11 0.601503234 1 7.57832702e-06)
    list(2.725e-11 0.599865851 1 6.97375485e-06)
    list(2.925e-11 0.598230207 1 6.23295639e-06)
    list(3.015e-11 0.597477986 0.97 2.55038576e-05)
    list(3.175e-11 0.596513931 0.65 2.508913e-05)
    list(3.375e-11 0.596146427 0.25 1.8874564e-05)
    list(3.505e-11 0.596049282 0 4.2085093e-05)
    list(3.625e-11 0.59604926 0 3.11805535e-05)
    list(3.825e-11 0.596049232 0 2.18693277e-05)
    list(4.025e-11 0.596049207 0 2.00392876e-05)
    list(4.225e-11 0.596049182 0 1.94205984e-05)
    list(4.425e-11 0.596049156 0 1.91127138e-05)
    list(4.625e-11 0.596049131 0 1.89455015e-05)
    list(4.825e-11 0.596049106 0 1.88490718e-05)
    list(5.025e-11 0.596049081 0 1.87876756e-05)
    list(5.225e-11 0.596049057 0 1.87409965e-05)
    list(5.425e-11 0.596049032 0 1.86956254e-05)
    list(5.625e-11 0.596049007 0 1.86411744e-05)
    list(5.825e-11 0.596048982 0 1.85694533e-05)
    list(6.025e-11 0.596048956 0 1.84761381e-05)
    list(6.225e-11 0.59604893 0 1.8363196e-05)
    list(6.425e-11 0.596048904 0 1.82388861e-05)
    list(6.625e-11 0.596048878 0 1.81142831e-05)
    list(6.825e-11 0.59604885 0 1.79990018e-05)
    list(7.025e-11 0.596048823 0 1.78988952e-05)
    list(7.225e-11 0.596048794 0 1.78160242e-05)
    list(7.425e-11 0.596048766 0 1.77497739e-05)
    list(7.625e-11 0.596048737 0 1.76981042e-05)
    list(7.825e-11 0.596048708 0 1.76584811e-05)
    list(8.025e-11 0.596048679 0 1.76284245e-05)
    list(8.225e-11 0.59604865 0 1.76057656e-05)
    list(8.425e-11 0.59604862 0 1.75887266e-05)
    list(8.625e-11 0.596048591 0 1.75759072e-05)
    list(8.825e-11 0.596048561 0 1.75662335e-05)
    list(9.025e-11 0.596048532 0 1.75588958e-05)
    list(9.225e-11 0.596048502 0 1.75532905e-05)
    list(9.425e-11 0.596048473 0 1.7548971e-05)
    list(9.625e-11 0.596048443 0 1.75456082e-05)
    list(9.825e-11 0.596048414 0 1.75429601e-05)
    list(1e-10 0.596048388 2.58493941e-15 1.75407139e-05)
    list(1.0075e-10 0.596105075 0.15 7.19265218e-06)
    list(1.0275e-10 0.596094567 0.55 -3.49792353e-06)
    list(1.0475e-10 0.59493806 0.95 -5.54362635e-06)
    list(1.0535e-10 0.594302985 1 7.77835759e-06)
    list(1.0725e-10 0.592431082 1 1.00953221e-05)
    list(1.0925e-10 0.590691868 1 1.02830972e-05)
    list(1.1125e-10 0.58902922 1 1.00328713e-05)
    list(1.1325e-10 0.587392635 1 9.71367647e-06)
    list(1.1525e-10 0.585765954 1 9.39041673e-06)
    list(1.1725e-10 0.584143786 1 9.07020838e-06)
    list(1.1925e-10 0.582524295 1 8.74811292e-06)
    list(1.2125e-10 0.58090685 1 8.41248963e-06)
    list(1.2325e-10 0.579291233 1 8.03885855e-06)
    list(1.2525e-10 0.577677365 1 7.57821432e-06)
    list(1.2725e-10 0.576065219 1 6.97198629e-06)
    list(1.2925e-10 0.574454785 1 6.22960698e-06)
    list(1.3015e-10 0.57371359 0.97 2.55318555e-05)
    list(1.3175e-10 0.572750547 0.65 2.44637968e-05)
    list(1.3375e-10 0.572376495 0.25 1.91133995e-05)
    list(1.3505e-10 0.572277842 0 4.22817298e-05)
    list(1.3625e-10 0.572277821 0 3.11667962e-05)
    list(1.3825e-10 0.572277794 0 2.18322057e-05)
    list(1.4025e-10 0.572277769 0 2.00243715e-05)
    list(1.4225e-10 0.572277745 0 1.94125676e-05)
    list(1.4425e-10 0.57227772 0 1.9107971e-05)
    list(1.4625e-10 0.572277696 0 1.89426052e-05)
    list(1.4825e-10 0.572277671 0 1.88472339e-05)
    list(1.5025e-10 0.572277647 0 1.87864065e-05)
    list(1.5225e-10 0.572277623 0 1.87399456e-05)
    list(1.5425e-10 0.572277599 0 1.86944993e-05)
    list(1.5625e-10 0.572277574 0 1.8639712e-05)
    list(1.5825e-10 0.57227755 0 1.85674595e-05)
    list(1.6025e-10 0.572277526 0 1.84735657e-05)
    list(1.6225e-10 0.572277501 0 1.83601973e-05)
    list(1.6425e-10 0.572277475 0 1.82357573e-05)
    list(1.6625e-10 0.57227745 0 1.81113334e-05)
    list(1.6825e-10 0.572277423 0 1.79964518e-05)
    list(1.7025e-10 0.572277397 0 1.7896848e-05)
    list(1.7225e-10 0.572277369 0 1.78144874e-05)
    list(1.7425e-10 0.572277342 0 1.77486979e-05)
    list(1.7625e-10 0.572277314 0 1.76974146e-05)
    list(1.7825e-10 0.572277286 0 1.76580995e-05)
    list(1.8025e-10 0.572277258 0 1.76282795e-05)
    list(1.8225e-10 0.57227723 0 1.76057973e-05)
    list(1.8425e-10 0.572277202 0 1.75888868e-05)
    list(1.8625e-10 0.572277174 0 1.75761584e-05)
    list(1.8825e-10 0.572277146 0 1.75665472e-05)
    list(1.9025e-10 0.572277117 0 1.75592503e-05)
    list(1.9225e-10 0.572277089 0 1.75536696e-05)
    list(1.9425e-10 0.572277061 0 1.75493628e-05)
    list(1.9625e-10 0.572277032 0 1.75460037e-05)
    list(1.9825e-10 0.572277004 0 1.75433529e-05)
    list(2e-10 0.572276979 0 1.75410933e-05)
    list(2.0075e-10 0.572334383 0.15 7.17795126e-06)
    list(2.0275e-10 0.572333178 0.55 -3.68189148e-06)
    list(2.0475e-10 0.57120009 0.95 -4.92179244e-06)
    list(2.0535e-10 0.570575908 1 8.41190061e-06)
    list(2.0725e-10 0.568732424 1 1.02346522e-05)
    list(2.0925e-10 0.567019269 1 1.03066811e-05)
    list(2.1125e-10 0.565381811 1 1.00308773e-05)
    list(2.1325e-10 0.563770245 1 9.70533261e-06)
    list(2.1525e-10 0.562168545 1 9.37992847e-06)
    list(2.1725e-10 0.560571339 1 9.05859064e-06)
    list(2.1925e-10 0.558976788 1 8.7357063e-06)
    list(2.2125e-10 0.557384259 1 8.39951156e-06)
    list(2.2325e-10 0.55579353 1 8.02556193e-06)
    list(2.2525e-10 0.554204524 1 7.5649472e-06)
    list(2.2725e-10 0.552617213 1 6.95898778e-06)
    list(2.2925e-10 0.551031585 1 6.21668495e-06)
    list(2.3015e-10 0.550301164 0.97 2.55700333e-05)
    list(2.3175e-10 0.549338151 0.65 2.41060951e-05)
    list(2.3375e-10 0.548957772 0.25 1.96022123e-05)
    list(2.3505e-10 0.548857579 0 4.25063588e-05)
    list(2.3625e-10 0.548857558 0 3.11574354e-05)
    list(2.3825e-10 0.548857531 0 2.17995421e-05)
    list(2.4025e-10 0.548857508 0 2.00148623e-05)
    list(2.4225e-10 0.548857484 0 1.94095883e-05)
    list(2.4425e-10 0.54885746 0 1.9107736e-05)
    list(2.4625e-10 0.548857437 0 1.89436401e-05)
    list(2.4825e-10 0.548857414 0 1.8848762e-05)
    list(2.5025e-10 0.54885739 0 1.87879664e-05)
    list(2.5225e-10 0.548857367 0 1.87412181e-05)
    list(2.5425e-10 0.548857344 0 1.86952204e-05)
    list(2.5625e-10 0.54885732 0 1.86396472e-05)
    list(2.5825e-10 0.548857297 0 1.85664435e-05)
    list(2.6025e-10 0.548857273 0 1.84715936e-05)
    list(2.6225e-10 0.548857249 0 1.83574795e-05)
    list(2.6425e-10 0.548857225 0 1.82326541e-05)
    list(2.6625e-10 0.5488572 0 1.81082121e-05)
    list(2.6825e-10 0.548857175 0 1.79935767e-05)
    list(2.7025e-10 0.54885715 0 1.78943515e-05)
    list(2.7225e-10 0.548857124 0 1.7812396e-05)
    list(2.7425e-10 0.548857098 0 1.77469741e-05)
    list(2.7625e-10 0.548857071 0 1.76959924e-05)
    list(2.7825e-10 0.548857045 0 1.76569074e-05)
    list(2.8025e-10 0.548857018 0 1.76272524e-05)
    list(2.8225e-10 0.548856991 0 1.76048811e-05)
    list(2.8425e-10 0.548856964 0 1.75880393e-05)
    list(2.8625e-10 0.548856937 0 1.75753479e-05)
    list(2.8825e-10 0.54885691 0 1.75657506e-05)
    list(2.9025e-10 0.548856883 0 1.75584514e-05)
    list(2.9225e-10 0.548856856 0 1.75528573e-05)
    list(2.9425e-10 0.548856829 0 1.75485296e-05)
    list(2.9625e-10 0.548856802 0 1.75451452e-05)
    list(2.9825e-10 0.548856776 0 1.75424664e-05)
    list(3e-10 0.548856752 0 1.75401668e-05)
    list(3.0075e-10 0.548914887 0.15 7.16463511e-06)
    list(3.0275e-10 0.548923188 0.55 -3.83918767e-06)
    list(3.0475e-10 0.5478119 0.95 -4.59630809e-06)
    list(3.0535e-10 0.54719865 1 9.06121134e-06)
    list(3.0725e-10 0.545383677 1 1.03687477e-05)
    list(3.0925e-10 0.543696446 1 1.03230876e-05)
    list(3.1125e-10 0.542083942 1 1.0022684e-05)
    list(3.1325e-10 0.540497092 1 9.69189456e-06)
    list(3.1525e-10 0.538920033 1 9.36530142e-06)
    list(3.1725e-10 0.537347432 1 9.04365777e-06)
    list(3.1925e-10 0.53577746 1 8.72070398e-06)
    list(3.2125e-10 0.534209485 1 8.38456957e-06)
    list(3.2325e-10 0.532643287 1 8.01085513e-06)
    list(3.2525e-10 0.53107879 1 7.55075154e-06)
    list(3.2725e-10 0.529515967 1 6.94548221e-06)
    list(3.2925e-10 0.527954808 1 6.2036359e-06)
    list(3.3015e-10 0.527234892 0.97 2.56332278e-05)
    list(3.3175e-10 0.526270994 0.65 2.37893838e-05)
    list(3.3375e-10 0.525884511 0.25 2.01285457e-05)
    list(3.3505e-10 0.52578273 0 4.27658714e-05)
    list(3.3625e-10 0.52578271 0 3.11479479e-05)
    list(3.3825e-10 0.525782685 0 2.17664819e-05)
    list(3.4025e-10 0.525782662 0 2.00073523e-05)
    list(3.4225e-10 0.525782639 0 1.94089541e-05)
    list(3.4425e-10 0.525782617 0 1.91098243e-05)
    list(3.4625e-10 0.525782594 0 1.89468463e-05)
    list(3.4825e-10 0.525782572 0 1.88522505e-05)
    list(3.5025e-10 0.52578255 0 1.87912477e-05)
    list(3.5225e-10 0.525782528 0 1.87439565e-05)
    list(3.5425e-10 0.525782505 0 1.86971383e-05)
    list(3.5625e-10 0.525782483 0 1.86404979e-05)
    list(3.5825e-10 0.525782461 0 1.85660607e-05)
    list(3.6025e-10 0.525782438 0 1.84699956e-05)
    list(3.6225e-10 0.525782416 0 1.8354929e-05)
    list(3.6425e-10 0.525782393 0 1.82295789e-05)
    list(3.6625e-10 0.525782369 0 1.81050408e-05)
    list(3.6825e-10 0.525782345 0 1.79906166e-05)
    list(3.7025e-10 0.525782321 0 1.78917581e-05)
    list(3.7225e-10 0.525782297 0 1.78102044e-05)
    list(3.7425e-10 0.525782272 0 1.77451467e-05)
    list(3.7625e-10 0.525782247 0 1.76944594e-05)
    list(3.7825e-10 0.525782222 0 1.76555928e-05)
    list(3.8025e-10 0.525782196 0 1.76260872e-05)
    list(3.8225e-10 0.525782171 0 1.76038084e-05)
    list(3.8425e-10 0.525782146 0 1.75870151e-05)
    list(3.8625e-10 0.52578212 0 1.75743399e-05)
    list(3.8825e-10 0.525782095 0 1.75647358e-05)
    list(3.9025e-10 0.525782069 0 1.75574143e-05)
    list(3.9225e-10 0.525782044 0 1.75517878e-05)
    list(3.9425e-10 0.525782018 0 1.75474218e-05)
    list(3.9625e-10 0.525781993 0 1.75439958e-05)
    list(3.9825e-10 0.525781967 0 1.75412742e-05)
    list(4e-10 0.525781945 0 1.75389176e-05)
    list(4.0075e-10 0.525840831 0.15 7.1524594e-06)
    list(4.0275e-10 0.525858785 0.55 -3.97392244e-06)
    list(4.0475e-10 0.52476791 0.95 -4.42958217e-06)
    list(4.0535e-10 0.524165679 1 9.71488954e-06)
    list(4.0725e-10 0.522379504 1 1.04982101e-05)
    list(4.0925e-10 0.520718415 1 1.03349061e-05)
    list(4.1125e-10 0.519130883 1 1.00107924e-05)
    list(4.1325e-10 0.51756863 1 9.67543521e-06)
    list(4.1525e-10 0.51601602 1 9.34816372e-06)
    list(4.1725e-10 0.514467799 1 9.02663376e-06)
    list(4.1925e-10 0.512922173 1 8.70397332e-06)
    list(4.2125e-10 0.511378523 1 8.36821936e-06)
    list(4.2325e-10 0.509836638 1 7.99502196e-06)
    list(4.2525e-10 0.508296443 1 7.53567603e-06)
    list(4.2725e-10 0.506757915 1 6.93131572e-06)
    list(4.2925e-10 0.505221043 1 6.19013194e-06)
    list(4.3015e-10 0.504511391 0.97 2.57335359e-05)
    list(4.3175e-10 0.503545656 0.65 2.33595268e-05)
    list(4.3375e-10 0.503153285 0.25 2.05487291e-05)
    list(4.3505e-10 0.503049857 0 4.30636194e-05)
    list(4.3625e-10 0.503049837 0 3.11285106e-05)
    list(4.3825e-10 0.503049813 0 2.172461e-05)
    list(4.4025e-10 0.503049792 0 1.99956622e-05)
    list(4.4225e-10 0.50304977 0 1.94056104e-05)
    list(4.4425e-10 0.503049749 0 1.91100179e-05)
    list(4.4625e-10 0.503049728 0 1.89486853e-05)
    list(4.4825e-10 0.503049707 0 1.88547289e-05)
    list(4.5025e-10 0.503049686 0 1.87937607e-05)
    list(4.5225e-10 0.503049665 0 1.87460791e-05)
    list(4.5425e-10 0.503049644 0 1.86985141e-05)
    list(4.5625e-10 0.503049623 0 1.86408108e-05)
    list(4.5825e-10 0.503049602 0 1.85650968e-05)
    list(4.6025e-10 0.503049581 0 1.84677672e-05)
    list(4.6225e-10 0.503049559 0 1.83517403e-05)
    list(4.6425e-10 0.503049537 0 1.82259251e-05)
    list(4.6625e-10 0.503049515 0 1.81014123e-05)
    list(4.6825e-10 0.503049493 0 1.79873576e-05)
    list(4.7025e-10 0.50304947 0 1.78890348e-05)
    list(4.7225e-10 0.503049447 0 1.7808043e-05)
    list(4.7425e-10 0.503049424 0 1.77434908e-05)
    list(4.7625e-10 0.5030494 0 1.76932171e-05)
    list(4.7825e-10 0.503049377 0 1.76546663e-05)
    list(4.8025e-10 0.503049353 0 1.76253881e-05)
    list(4.8225e-10 0.503049329 0 1.76032637e-05)
    list(4.8425e-10 0.503049306 0 1.75865678e-05)
    list(4.8625e-10 0.503049282 0 1.75739471e-05)
    list(4.8825e-10 0.503049258 0 1.75643663e-05)
    list(4.9025e-10 0.503049234 0 1.75570458e-05)
    list(4.9225e-10 0.50304921 0 1.75514052e-05)
    list(4.9425e-10 0.503049186 0 1.75470148e-05)
    list(4.9625e-10 0.503049162 0 1.75435579e-05)
    list(4.9825e-10 0.503049138 0 1.75408015e-05)
    list(5e-10 0.503049117 0 1.75383943e-05)
    list(5.0075e-10 0.503108781 0.15 7.14120386e-06)
    list(5.0275e-10 0.503136471 0.55 -4.09033449e-06)
    list(5.0475e-10 0.502064877 0.95 -4.26193765e-06)
    list(5.0535e-10 0.501473872 1 1.03675887e-05)
    list(5.0725e-10 0.499717154 1 1.06288528e-05)
    list(5.0925e-10 0.498082789 1 1.03492557e-05)
    list(5.1125e-10 0.496520587 1 1.00016392e-05)
    list(5.1325e-10 0.4949831 1 9.66143586e-06)
    list(5.1525e-10 0.493455001 1 9.33308508e-06)
    list(5.1725e-10 0.49193118 1 9.01126945e-06)
    list(5.1925e-10 0.49040991 1 8.68853973e-06)
    list(5.2125e-10 0.488890603 1 8.3528465e-06)
    list(5.2325e-10 0.487373064 1 7.97988485e-06)
    list(5.2525e-10 0.485857224 1 7.52104859e-06)
    list(5.2725e-10 0.484343064 1 6.91738233e-06)
    list(5.2925e-10 0.482830578 1 6.17668639e-06)
    list(5.3015e-10 0.48213105 0.97 2.58321034e-05)
    list(5.3175e-10 0.481162527 0.65 2.28925879e-05)
    list(5.3375e-10 0.480764452 0.25 2.09829794e-05)
    list(5.3505e-10 0.480659303 0 4.34155542e-05)
    list(5.3625e-10 0.480659285 0 3.10939244e-05)
    list(5.3825e-10 0.480659262 0 2.16703105e-05)
    list(5.4025e-10 0.480659242 0 1.99780035e-05)
    list(5.4225e-10 0.480659222 0 1.93983076e-05)
    list(5.4425e-10 0.480659202 0 1.91073531e-05)
    list(5.4625e-10 0.480659182 0 1.8948368e-05)
    list(5.4825e-10 0.480659162 0 1.88555174e-05)
    list(5.5025e-10 0.480659142 0 1.87948914e-05)
    list(5.5225e-10 0.480659123 0 1.8747003e-05)
    list(5.5425e-10 0.480659103 0 1.86987659e-05)
    list(5.5625e-10 0.480659084 0 1.8639979e-05)
    list(5.5825e-10 0.480659064 0 1.85629037e-05)
    list(5.6025e-10 0.480659044 0 1.84642229e-05)
    list(5.6225e-10 0.480659024 0 1.8347214e-05)
    list(5.6425e-10 0.480659004 0 1.82210121e-05)
    list(5.6625e-10 0.480658983 0 1.80966926e-05)
    list(5.6825e-10 0.480658963 0 1.79832288e-05)
    list(5.7025e-10 0.480658941 0 1.78856781e-05)
    list(5.7225e-10 0.48065892 0 1.78054728e-05)
    list(5.7425e-10 0.480658898 0 1.77416241e-05)
    list(5.7625e-10 0.480658876 0 1.76919307e-05)
    list(5.7825e-10 0.480658854 0 1.7653832e-05)
    list(5.8025e-10 0.480658832 0 1.76248908e-05)
    list(5.8225e-10 0.48065881 0 1.76030081e-05)
    list(5.8425e-10 0.480658788 0 1.75864785e-05)
    list(5.8625e-10 0.480658766 0 1.75739669e-05)
    list(5.8825e-10 0.480658744 0 1.75644526e-05)
    list(5.9025e-10 0.480658722 0 1.75571674e-05)
    list(5.9225e-10 0.480658699 0 1.75515397e-05)
    list(5.9425e-10 0.480658677 0 1.75471464e-05)
    list(5.9625e-10 0.480658655 0 1.75436756e-05)
    list(5.9825e-10 0.480658633 0 1.75408979e-05)
    list(6e-10 0.480658614 0 1.75384516e-05)
    list(6.0075e-10 0.480719088 0.15 7.13064079e-06)
    list(6.0275e-10 0.48075653 0.55 -4.19331094e-06)
    list(6.0475e-10 0.479703395 0.95 -4.01801749e-06)
    list(6.0535e-10 0.479123994 1 1.10155477e-05)
    list(6.0725e-10 0.477398103 1 1.07644683e-05)
    list(6.0925e-10 0.475791713 1 1.03710754e-05)
    list(6.1125e-10 0.474255685 1 9.99986944e-06)
    list(6.1325e-10 0.472743521 1 9.65402582e-06)
    list(6.1525e-10 0.471240353 1 9.32368187e-06)
    list(6.1725e-10 0.469741301 1 9.00071206e-06)
    list(6.1925e-10 0.46824475 1 8.67712906e-06)
    list(6.2125e-10 0.466750168 1 8.34080082e-06)
    list(6.2325e-10 0.465257378 1 7.96746047e-06)
    list(6.2525e-10 0.463766327 1 7.50858778e-06)
    list(6.2725e-10 0.462276999 1 6.90513344e-06)
    list(6.2925e-10 0.460789392 1 6.16451037e-06)
    list(6.3015e-10 0.460100099 0.97 2.58175153e-05)
    list(6.3175e-10 0.459127864 0.65 2.24789491e-05)
    list(6.3375e-10 0.458724218 0.25 2.15797555e-05)
    list(6.3505e-10 0.458617261 0 4.38362949e-05)
    list(6.3625e-10 0.458617243 0 3.10425585e-05)
    list(6.3825e-10 0.458617222 0 2.16054396e-05)
    list(6.4025e-10 0.458617203 0 1.99567518e-05)
    list(6.4225e-10 0.458617185 0 1.93892619e-05)
    list(6.4425e-10 0.458617166 0 1.91038057e-05)
    list(6.4625e-10 0.458617148 0 1.89476177e-05)
    list(6.4825e-10 0.458617129 0 1.88560871e-05)
    list(6.5025e-10 0.458617111 0 1.87958647e-05)
    list(6.5225e-10 0.458617093 0 1.87477141e-05)
    list(6.5425e-10 0.458617075 0 1.86986462e-05)
    list(6.5625e-10 0.458617057 0 1.86385276e-05)
    list(6.5825e-10 0.458617039 0 1.85597944e-05)
    list(6.6025e-10 0.45861702 0 1.84594925e-05)
    list(6.6225e-10 0.458617002 0 1.83413381e-05)
    list(6.6425e-10 0.458616983 0 1.82147273e-05)
    list(6.6625e-10 0.458616964 0 1.80907005e-05)
    list(6.6825e-10 0.458616945 0 1.79780003e-05)
    list(6.7025e-10 0.458616926 0 1.78814203e-05)
    list(6.7225e-10 0.458616906 0 1.78021929e-05)
    list(6.7425e-10 0.458616886 0 1.7739215e-05)
    list(6.7625e-10 0.458616866 0 1.7690239e-05)
    list(6.7825e-10 0.458616846 0 1.76527e-05)
    list(6.8025e-10 0.458616825 0 1.76241779e-05)
    list(6.8225e-10 0.458616805 0 1.7602598e-05)
    list(6.8425e-10 0.458616785 0 1.75862797e-05)
    list(6.8625e-10 0.458616764 0 1.75739095e-05)
    list(6.8825e-10 0.458616744 0 1.75644845e-05)
    list(6.9025e-10 0.458616723 0 1.75572507e-05)
    list(6.9225e-10 0.458616703 0 1.75516469e-05)
    list(6.9425e-10 0.458616683 0 1.7547258e-05)
    list(6.9625e-10 0.458616662 0 1.7543778e-05)
    list(6.9825e-10 0.458616642 0 1.75409814e-05)
    list(7e-10 0.458616624 0 1.75384965e-05)
    list(7.0075e-10 0.458677949 0.15 7.12051925e-06)
    list(7.0275e-10 0.458725085 0.55 -4.2888657e-06)
    list(7.0475e-10 0.457690026 0.95 -3.69869376e-06)
    list(7.0535e-10 0.457122821 1 1.16555923e-05)
    list(7.0725e-10 0.455430049 1 1.09022593e-05)
    list(7.0925e-10 0.4538535 1 1.03984077e-05)
    list(7.1125e-10 0.452344945 1 1.00041452e-05)
    list(7.1325e-10 0.450859092 1 9.65235333e-06)
    list(7.1525e-10 0.449381715 1 9.31951089e-06)
    list(7.1725e-10 0.447908266 1 8.99487073e-06)
    list(7.1925e-10 0.446437286 1 8.66995544e-06)
    list(7.2125e-10 0.444968309 1 8.33255784e-06)
    list(7.2325e-10 0.443501188 1 7.95844633e-06)
    list(7.2525e-10 0.442035884 1 7.49918008e-06)
    list(7.2725e-10 0.440572388 1 6.89561486e-06)
    list(7.2925e-10 0.439110702 1 6.15478261e-06)
    list(7.3015e-10 0.438432144 0.97 2.56381669e-05)
    list(7.3175e-10 0.437455339 0.65 2.20748962e-05)
    list(7.3375e-10 0.437046176 0.25 2.23393257e-05)
    list(7.3505e-10 0.436937315 0 4.43245407e-05)
    list(7.3625e-10 0.436937298 0 3.0969417e-05)
    list(7.3825e-10 0.436937278 0 2.15310797e-05)
    list(7.4025e-10 0.436937261 0 1.99327131e-05)
    list(7.4225e-10 0.436937244 0 1.93791008e-05)
    list(7.4425e-10 0.436937227 0 1.90999208e-05)
    list(7.4625e-10 0.43693721 0 1.89469058e-05)
    list(7.4825e-10 0.436937193 0 1.88568439e-05)
    list(7.5025e-10 0.436937176 0 1.87970248e-05)
    list(7.5225e-10 0.43693716 0 1.87484945e-05)
    list(7.5425e-10 0.436937143 0 1.86983734e-05)
    list(7.5625e-10 0.436937126 0 1.86366125e-05)
    list(7.5825e-10 0.43693711 0 1.8555872e-05)
    list(7.6025e-10 0.436937093 0 1.84536471e-05)
    list(7.6225e-10 0.436937076 0 1.8334174e-05)
    list(7.6425e-10 0.436937059 0 1.82071373e-05)
    list(7.6625e-10 0.436937042 0 1.80835122e-05)
    list(7.6825e-10 0.436937024 0 1.79717557e-05)
    list(7.7025e-10 0.436937007 0 1.78763476e-05)
    list(7.7225e-10 0.436936989 0 1.77982894e-05)
    list(7.7425e-10 0.43693697 0 1.77363462e-05)
    list(7.7625e-10 0.436936952 0 1.76882197e-05)
    list(7.7825e-10 0.436936934 0 1.76513429e-05)
    list(7.8025e-10 0.436936915 0 1.76233165e-05)
    list(7.8225e-10 0.436936897 0 1.76020954e-05)
    list(7.8425e-10 0.436936878 0 1.75860285e-05)
    list(7.8625e-10 0.43693686 0 1.75738278e-05)
    list(7.8825e-10 0.436936841 0 1.75645115e-05)
    list(7.9025e-10 0.436936822 0 1.7557342e-05)
    list(7.9225e-10 0.436936804 0 1.75517704e-05)
    list(7.9425e-10 0.436936785 0 1.75473909e-05)
    list(7.9625e-10 0.436936767 0 1.75439042e-05)
    list(7.9825e-10 0.436936748 0 1.754109e-05)
    list(8e-10 0.436936732 0 1.7538565e-05)
    list(8.0075e-10 0.436998952 0.15 7.11055614e-06)
    list(8.0275e-10 0.437055643 0.55 -4.3846049e-06)
    list(8.0475e-10 0.436038822 0.95 -3.31603438e-06)
    list(8.0535e-10 0.435484737 1 1.22958703e-05)
    list(8.0725e-10 0.433828389 1 1.10379611e-05)
    list(8.0925e-10 0.432284141 1 1.04258858e-05)
    list(8.1125e-10 0.430804836 1 1.00098364e-05)
    list(8.1325e-10 0.429346791 1 9.65267056e-06)
    list(8.1525e-10 0.427896633 1 9.31763689e-06)
    list(8.1725e-10 0.426450226 1 8.99153328e-06)
    list(8.1925e-10 0.42500629 1 8.66544457e-06)
    list(8.2125e-10 0.423564436 1 8.327104e-06)
    list(8.2325e-10 0.42212455 1 7.95231858e-06)
    list(8.2525e-10 0.420686605 1 7.49272848e-06)
    list(8.2725e-10 0.419250599 1 6.88910032e-06)
    list(8.2925e-10 0.417816538 1 6.14809733e-06)
    list(8.3015e-10 0.417149601 0.97 2.53692646e-05)
    list(8.3175e-10 0.416167483 0.65 2.16427744e-05)
    list(8.3375e-10 0.415752762 0.25 2.32535258e-05)
    list(8.3505e-10 0.41564189 0 4.48663885e-05)
    list(8.3625e-10 0.415641874 0 3.08684099e-05)
    list(8.3825e-10 0.415641856 0 2.14481258e-05)
    list(8.4025e-10 0.41564184 0 1.99056781e-05)
    list(8.4225e-10 0.415641825 0 1.93673651e-05)
    list(8.4425e-10 0.415641809 0 1.90951791e-05)
    list(8.4625e-10 0.415641794 0 1.89457195e-05)
    list(8.4825e-10 0.415641778 0 1.88573071e-05)
    list(8.5025e-10 0.415641763 0 1.87979318e-05)
    list(8.5225e-10 0.415641748 0 1.87489466e-05)
    list(8.5425e-10 0.415641733 0 1.86975909e-05)
    list(8.5625e-10 0.415641718 0 1.86339214e-05)
    list(8.5825e-10 0.415641703 0 1.85508794e-05)
    list(8.6025e-10 0.415641688 0 1.84465001e-05)
    list(8.6225e-10 0.415641673 0 1.83256134e-05)
    list(8.6425e-10 0.415641657 0 1.81982045e-05)
    list(8.6625e-10 0.415641642 0 1.8075143e-05)
    list(8.6825e-10 0.415641626 0 1.79645446e-05)
    list(8.7025e-10 0.41564161 0 1.78705308e-05)
    list(8.7225e-10 0.415641593 0 1.77938426e-05)
    list(8.7425e-10 0.415641577 0 1.77331048e-05)
    list(8.7625e-10 0.415641561 0 1.76859657e-05)
    list(8.7825e-10 0.415641544 0 1.76498587e-05)
    list(8.8025e-10 0.415641527 0 1.76224107e-05)
    list(8.8225e-10 0.415641511 0 1.7601611e-05)
    list(8.8425e-10 0.415641494 0 1.75858423e-05)
    list(8.8625e-10 0.415641477 0 1.75738464e-05)
    list(8.8825e-10 0.41564146 0 1.75646651e-05)
    list(8.9025e-10 0.415641444 0 1.75575794e-05)
    list(8.9225e-10 0.415641427 0 1.75520548e-05)
    list(8.9425e-10 0.41564141 0 1.75476958e-05)
    list(8.9625e-10 0.415641393 0 1.7544211e-05)
    list(8.9825e-10 0.415641377 0 1.75413855e-05)
    list(9e-10 0.415641362 0 1.75388256e-05)
    list(9.0075e-10 0.415704526 0.15 7.1004407e-06)
    list(9.0275e-10 0.415770552 0.55 -4.48929687e-06)
    list(9.0475e-10 0.414772673 0.95 -2.85305233e-06)
    list(9.0535e-10 0.414233132 1 1.29634859e-05)
    list(9.0725e-10 0.412617379 1 1.11729576e-05)
    list(9.0925e-10 0.411108316 1 1.04510719e-05)
    list(9.1125e-10 0.409660495 1 1.00143107e-05)
    list(9.1325e-10 0.40823231 1 9.65263156e-06)
    list(9.1525e-10 0.406811411 1 9.31603367e-06)
    list(9.1725e-10 0.405394121 1 8.98896629e-06)
    list(9.1925e-10 0.403979352 1 8.66212206e-06)
    list(9.2125e-10 0.402566788 1 8.32319254e-06)
    list(9.2325e-10 0.401156344 1 7.94802982e-06)
    list(9.2525e-10 0.399748003 1 7.48835783e-06)
    list(9.2725e-10 0.39834177 1 6.88486243e-06)
    list(9.2925e-10 0.396937655 1 6.14385325e-06)
    list(9.3015e-10 0.396283487 0.97 2.50829974e-05)
    list(9.3175e-10 0.395295543 0.65 2.11666589e-05)
    list(9.3375e-10 0.394875119 0.25 2.46826863e-05)
    list(9.3505e-10 0.394762127 0 4.54355264e-05)
    list(9.3625e-10 0.394762111 0 3.07291152e-05)
    list(9.3825e-10 0.394762095 0 2.13530008e-05)
    list(9.4025e-10 0.394762081 0 1.98709815e-05)
    list(9.4225e-10 0.394762066 0 1.93494533e-05)
    list(9.4425e-10 0.394762052 0 1.9085243e-05)
    list(9.4625e-10 0.394762038 0 1.89400253e-05)
    list(9.4825e-10 0.394762025 0 1.88537475e-05)
    list(9.5025e-10 0.394762011 0 1.87951449e-05)
    list(9.5225e-10 0.394761997 0 1.87458962e-05)
    list(9.5425e-10 0.394761984 0 1.86933709e-05)
    list(9.5625e-10 0.394761971 0 1.86277596e-05)
    list(9.5825e-10 0.394761957 0 1.85423518e-05)
    list(9.6025e-10 0.394761944 0 1.8435815e-05)
    list(9.6225e-10 0.39476193 0 1.83136333e-05)
    list(9.6425e-10 0.394761916 0 1.81860879e-05)
    list(9.6625e-10 0.394761902 0 1.80638949e-05)
    list(9.6825e-10 0.394761888 0 1.79547767e-05)
    list(9.7025e-10 0.394761874 0 1.78624607e-05)
    list(9.7225e-10 0.394761859 0 1.77874111e-05)
    list(9.7425e-10 0.394761845 0 1.77281058e-05)
    list(9.7625e-10 0.39476183 0 1.76821425e-05)
    list(9.7825e-10 0.394761815 0 1.764696e-05)
    list(9.8025e-10 0.3947618 0 1.76202172e-05)
    list(9.8225e-10 0.394761785 0 1.75999432e-05)
    list(9.8425e-10 0.39476177 0 1.75845593e-05)
    list(9.8625e-10 0.394761755 0 1.75728404e-05)
    list(9.8825e-10 0.39476174 0 1.75638552e-05)
    list(9.9025e-10 0.394761726 0 1.75569057e-05)
    list(9.9225e-10 0.394761711 0 1.75514733e-05)
    list(9.9425e-10 0.394761696 0 1.75471743e-05)
    list(9.9625e-10 0.394761681 0 1.75437262e-05)
    list(9.9825e-10 0.394761666 0 1.75409205e-05)
    list(1e-09 0.394761653 0 1.75383593e-05)
    list(1.00075e-09 0.394825813 0.15 7.0899198e-06)
    list(1.00275e-09 0.394900876 0.55 -4.61131988e-06)
    list(1.00475e-09 0.393923157 0.95 -2.27484925e-06)
    list(1.00535e-09 0.393400066 1 1.36904555e-05)
    list(1.00725e-09 0.391829553 1 1.13117216e-05)
    list(1.00925e-09 0.390358817 1 1.04742134e-05)
    list(1.01125e-09 0.38894507 1 1.00171225e-05)
    list(1.01325e-09 0.387549237 1 9.65154246e-06)
    list(1.01525e-09 0.386160115 1 9.31382826e-06)
    list(1.01725e-09 0.384774504 1 8.98614357e-06)
    list(1.01925e-09 0.383391497 1 8.65882836e-06)
    list(1.02125e-09 0.382010847 1 8.31954477e-06)
    list(1.02325e-09 0.380632491 1 7.94419592e-06)
    list(1.02525e-09 0.379256422 1 7.48459171e-06)
    list(1.02725e-09 0.377882648 1 6.88134452e-06)
    list(1.02925e-09 0.376511178 1 6.14042442e-06)
    list(1.03015e-09 0.375871054 0.97 2.48043989e-05)
    list(1.03175e-09 0.374877125 0.65 2.06214224e-05)
    list(1.03375e-09 0.374450761 0.25 2.65067364e-05)
    list(1.03505e-09 0.37433554 0 4.60150177e-05)
    list(1.03625e-09 0.374335524 0 3.05516734e-05)
    list(1.03825e-09 0.374335509 0 2.12500481e-05)
    list(1.04025e-09 0.374335497 0 1.98310201e-05)
    list(1.04225e-09 0.374335484 0 1.93271631e-05)
    list(1.04425e-09 0.374335472 0 1.9071574e-05)
    list(1.04625e-09 0.374335459 0 1.89310581e-05)
    list(1.04825e-09 0.374335447 0 1.88472356e-05)
    list(1.05025e-09 0.374335435 0 1.87896097e-05)
    list(1.05225e-09 0.374335423 0 1.87401918e-05)
    list(1.05425e-09 0.374335411 0 1.86864896e-05)
    list(1.05625e-09 0.374335399 0 1.86188587e-05)
    list(1.05825e-09 0.374335387 0 1.85310087e-05)
    list(1.06025e-09 0.374335375 0 1.8422324e-05)
    list(1.06225e-09 0.374335363 0 1.82989834e-05)
    list(1.06425e-09 0.374335351 0 1.81715383e-05)
    list(1.06625e-09 0.374335339 0 1.8050496e-05)
    list(1.06825e-09 0.374335326 0 1.79431387e-05)
    list(1.07025e-09 0.374335314 0 1.78527731e-05)
    list(1.07225e-09 0.374335301 0 1.77795773e-05)
    list(1.07425e-09 0.374335288 0 1.77218827e-05)
    list(1.07625e-09 0.374335275 0 1.76772406e-05)
    list(1.07825e-09 0.374335262 0 1.76431011e-05)
    list(1.08025e-09 0.374335248 0 1.76171603e-05)
    list(1.08225e-09 0.374335235 0 1.75974918e-05)
    list(1.08425e-09 0.374335222 0 1.7582559e-05)
    list(1.08625e-09 0.374335209 0 1.7571173e-05)
    list(1.08825e-09 0.374335196 0 1.75624316e-05)
    list(1.09025e-09 0.374335183 0 1.75556595e-05)
    list(1.09225e-09 0.374335169 0 1.7550355e-05)
    list(1.09425e-09 0.374335156 0 1.75461478e-05)
    list(1.09625e-09 0.374335143 0 1.75427645e-05)
    list(1.09825e-09 0.37433513 0 1.7540004e-05)
    list(1.1e-09 0.374335118 0 1.75374692e-05)
    list(1.10075e-09 0.37440033 0.15 7.07881564e-06)
    list(1.10275e-09 0.374484065 0.55 -4.75677375e-06)
    list(1.10475e-09 0.373528214 0.95 -1.55090233e-06)
    list(1.10535e-09 0.373023729 1 1.44941e-05)
    list(1.10725e-09 0.371503086 1 1.1456004e-05)
    list(1.10925e-09 0.370073802 1 1.04954516e-05)
    list(1.11125e-09 0.368696833 1 1.00181278e-05)
    list(1.11325e-09 0.367336027 1 9.64901995e-06)
    list(1.11525e-09 0.3659814 1 9.3104089e-06)
    list(1.11725e-09 0.364630217 1 8.98225035e-06)
    list(1.11925e-09 0.363281741 1 8.65457071e-06)
    list(1.12125e-09 0.361935779 1 8.31501661e-06)
    list(1.12325e-09 0.360592288 1 7.939544e-06)
    list(1.12525e-09 0.359251266 1 7.48004835e-06)
    list(1.12725e-09 0.35791272 1 6.87707348e-06)
    list(1.12925e-09 0.356576661 1 6.13626228e-06)
    list(1.13015e-09 0.355951855 0.97 2.45401798e-05)
    list(1.13175e-09 0.354952232 0.65 1.99926331e-05)
    list(1.13375e-09 0.354519623 0.25 2.85049166e-05)
    list(1.13505e-09 0.354402068 0 4.65912128e-05)
    list(1.13625e-09 0.354402054 0 3.03400123e-05)
    list(1.13825e-09 0.35440204 0 2.1142632e-05)
    list(1.14025e-09 0.354402029 0 1.97871772e-05)
    list(1.14225e-09 0.354402018 0 1.9301201e-05)
    list(1.14425e-09 0.354402007 0 1.90544453e-05)
    list(1.14625e-09 0.354401996 0 1.8918769e-05)
    list(1.14825e-09 0.354401985 0 1.88374711e-05)
    list(1.15025e-09 0.354401974 0 1.87808237e-05)
    list(1.15225e-09 0.354401964 0 1.87311671e-05)
    list(1.15425e-09 0.354401953 0 1.86761518e-05)
    list(1.15625e-09 0.354401943 0 1.86063329e-05)
    list(1.15825e-09 0.354401933 0 1.85159128e-05)
    list(1.16025e-09 0.354401922 0 1.84050674e-05)
    list(1.16225e-09 0.354401912 0 1.82806859e-05)
    list(1.16425e-09 0.354401901 0 1.81535444e-05)
    list(1.16625e-09 0.35440189 0 1.80338818e-05)
    list(1.16825e-09 0.354401879 0 1.79284991e-05)
    list(1.17025e-09 0.354401868 0 1.78402655e-05)
    list(1.17225e-09 0.354401857 0 1.77690707e-05)
    list(1.17425e-09 0.354401846 0 1.7713104e-05)
    list(1.17625e-09 0.354401834 0 1.76698767e-05)
    list(1.17825e-09 0.354401823 0 1.76368556e-05)
    list(1.18025e-09 0.354401812 0 1.76117786e-05)
    list(1.18225e-09 0.3544018 0 1.7592767e-05)
    list(1.18425e-09 0.354401789 0 1.75783293e-05)
    list(1.18625e-09 0.354401777 0 1.75673142e-05)
    list(1.18825e-09 0.354401766 0 1.75588503e-05)
    list(1.19025e-09 0.354401754 0 1.75522856e-05)
    list(1.19225e-09 0.354401743 0 1.75471367e-05)
    list(1.19425e-09 0.354401731 0 1.75430463e-05)
    list(1.19625e-09 0.35440172 0 1.75397513e-05)
    list(1.19825e-09 0.354401708 0 1.75370578e-05)
    list(1.2e-09 0.354401698 4.13590306e-14 1.75345748e-05)
    list(1.20075e-09 0.354468016 0.15 7.06704742e-06)
    list(1.20275e-09 0.354560007 0.55 -4.92891572e-06)
    list(1.20475e-09 0.3536282 0.95 -6.71741443e-07)
    list(1.20535e-09 0.353144455 1 1.53713724e-05)
    list(1.20725e-09 0.351677891 1 1.16034779e-05)
    list(1.20925e-09 0.350292887 1 1.05139451e-05)
    list(1.21125e-09 0.348955238 1 1.00168096e-05)
    list(1.21325e-09 0.347632036 1 9.64451522e-06)
    list(1.21525e-09 0.346314531 1 9.30513946e-06)
    list(1.21725e-09 0.345000426 1 8.9765687e-06)
    list(1.21925e-09 0.343689129 1 8.64856784e-06)
    list(1.22125e-09 0.342380494 1 8.30877533e-06)
    list(1.22325e-09 0.341074491 1 7.93320049e-06)
    list(1.22525e-09 0.339771121 1 7.47382251e-06)
    list(1.22725e-09 0.33847039 1 6.87112053e-06)
    list(1.22925e-09 0.337172309 1 6.1304218e-06)
    list(1.23015e-09 0.336563992 0.97 2.42952286e-05)
    list(1.23175e-09 0.33555945 0.65 1.92764796e-05)
    list(1.23375e-09 0.335120237 0.25 3.06343297e-05)
    list(1.23505e-09 0.335000257 0 4.71492231e-05)
    list(1.23625e-09 0.335000243 0 3.00974353e-05)
    list(1.23825e-09 0.335000231 0 2.10344062e-05)
    list(1.24025e-09 0.335000221 0 1.97415724e-05)
    list(1.24225e-09 0.335000211 0 1.92732774e-05)
    list(1.24425e-09 0.335000201 0 1.90353493e-05)
    list(1.24625e-09 0.335000192 0 1.89045174e-05)
    list(1.24825e-09 0.335000182 0 1.88257271e-05)
    list(1.25025e-09 0.335000173 0 1.87700014e-05)
    list(1.25225e-09 0.335000164 0 1.87199984e-05)
    list(1.25425e-09 0.335000155 0 1.86635153e-05)
    list(1.25625e-09 0.335000146 0 1.85913459e-05)
    list(1.25825e-09 0.335000137 0 1.849826e-05)
    list(1.26025e-09 0.335000128 0 1.83852854e-05)
    list(1.26225e-09 0.335000119 0 1.8260014e-05)
    list(1.26425e-09 0.33500011 0 1.81333866e-05)
    list(1.26625e-09 0.335000101 0 1.80153129e-05)
    list(1.26825e-09 0.335000091 0 1.79120817e-05)
    list(1.27025e-09 0.335000082 0 1.78261172e-05)
    list(1.27225e-09 0.335000072 0 1.77570261e-05)
    list(1.27425e-09 0.335000062 0 1.77028641e-05)
    list(1.27625e-09 0.335000053 0 1.76611101e-05)
    list(1.27825e-09 0.335000043 0 1.76292533e-05)
    list(1.28025e-09 0.335000033 0 1.76050773e-05)
    list(1.28225e-09 0.335000023 0 1.75867542e-05)
    list(1.28425e-09 0.335000013 0 1.75728386e-05)
    list(1.28625e-09 0.335000003 0 1.75622185e-05)
    list(1.28825e-09 0.334999994 0 1.75540536e-05)
    list(1.29025e-09 0.334999984 0 1.75477162e-05)
    list(1.29225e-09 0.334999974 0 1.7542741e-05)
    list(1.29425e-09 0.334999964 0 1.75387845e-05)
    list(1.29625e-09 0.334999954 0 1.75355939e-05)
    list(1.29825e-09 0.334999945 0 1.75329826e-05)
    list(1.3e-09 0.334999936 0 1.7530569e-05)
    list(1.30075e-09 0.335067414 0.15 7.05460113e-06)
    list(1.30275e-09 0.335167212 0.55 -5.12867395e-06)
    list(1.30475e-09 0.334262046 0.95 3.55421827e-07)
    list(1.30535e-09 0.333800949 1 1.63036516e-05)
    list(1.30725e-09 0.332391868 1 1.17492184e-05)
    list(1.30925e-09 0.331053452 1 1.05286672e-05)
    list(1.31125e-09 0.329757321 1 1.00128183e-05)
    list(1.31325e-09 0.328474005 1 9.63774956e-06)
    list(1.31525e-09 0.327195958 1 9.29772682e-06)
    list(1.31725e-09 0.325921278 1 8.96878703e-06)
    list(1.31925e-09 0.324649498 1 8.64048664e-06)
    list(1.32125e-09 0.323380507 1 8.30047217e-06)
    list(1.32325e-09 0.322114285 1 7.92480628e-06)
    list(1.32525e-09 0.320850832 1 7.46554933e-06)
    list(1.32725e-09 0.319590157 1 6.86311883e-06)
    list(1.32925e-09 0.318332265 1 6.12253749e-06)
    list(1.33015e-09 0.317741446 0.97 2.4068842e-05)
    list(1.33175e-09 0.31673323 0.65 1.84710821e-05)
    list(1.33375e-09 0.316287013 0.25 3.28434845e-05)
    list(1.33505e-09 0.316164529 0 4.7676561e-05)
    list(1.33625e-09 0.316164515 0 2.98279678e-05)
    list(1.33825e-09 0.316164505 0 2.09287327e-05)
    list(1.34025e-09 0.316164496 0 1.96965379e-05)
    list(1.34225e-09 0.316164488 0 1.92454506e-05)
    list(1.34425e-09 0.316164479 0 1.90161787e-05)
    list(1.34625e-09 0.316164471 0 1.88900821e-05)
    list(1.34825e-09 0.316164463 0 1.88136998e-05)
    list(1.35025e-09 0.316164455 0 1.87587774e-05)
    list(1.35225e-09 0.316164447 0 1.87082748e-05)
    list(1.35425e-09 0.31616444 0 1.86501425e-05)
    list(1.35625e-09 0.316164432 0 1.85754573e-05)
    list(1.35825e-09 0.316164424 0 1.84796304e-05)
    list(1.36025e-09 0.316164417 0 1.83645867e-05)
    list(1.36225e-09 0.316164409 0 1.8238592e-05)
    list(1.36425e-09 0.316164402 0 1.81126795e-05)
    list(1.36625e-09 0.316164394 0 1.79963736e-05)
    list(1.36825e-09 0.316164386 0 1.78954273e-05)
    list(1.37025e-09 0.316164378 0 1.78118219e-05)
    list(1.37225e-09 0.31616437 0 1.7744892e-05)
    list(1.37425e-09 0.316164362 0 1.76925707e-05)
    list(1.37625e-09 0.316164353 0 1.7652313e-05)
    list(1.37825e-09 0.316164345 0 1.76216362e-05)
    list(1.38025e-09 0.316164337 0 1.7598373e-05)
    list(1.38225e-09 0.316164329 0 1.75807476e-05)
    list(1.38425e-09 0.31616432 0 1.75673624e-05)
    list(1.38625e-09 0.316164312 0 1.75571449e-05)
    list(1.38825e-09 0.316164304 0 1.7549286e-05)
    list(1.39025e-09 0.316164296 0 1.75431826e-05)
    list(1.39225e-09 0.316164287 0 1.75383876e-05)
    list(1.39425e-09 0.316164279 0 1.75345714e-05)
    list(1.39625e-09 0.316164271 0 1.75314911e-05)
    list(1.39825e-09 0.316164263 0 1.75289677e-05)
    list(1.4e-09 0.316164255 0 1.75266306e-05)
    list(1.40075e-09 0.316232945 0.15 7.04151805e-06)
    list(1.40275e-09 0.316340079 0.55 -5.35486156e-06)
    list(1.40475e-09 0.315464465 0.95 1.50058629e-06)
    list(1.40535e-09 0.315027531 1 1.72664223e-05)
    list(1.40725e-09 0.313678424 1 1.18882293e-05)
    list(1.40925e-09 0.312388325 1 1.05388223e-05)
    list(1.41125e-09 0.311135484 1 1.00059754e-05)
    list(1.41325e-09 0.309893947 1 9.62861353e-06)
    list(1.41525e-09 0.308657305 1 9.28806396e-06)
    list(1.41725e-09 0.307424004 1 8.95879858e-06)
    list(1.41925e-09 0.306193677 1 8.63023094e-06)
    list(1.42125e-09 0.304966243 1 8.29002204e-06)
    list(1.42325e-09 0.303741686 1 7.91428743e-06)
    list(1.42525e-09 0.302520008 1 7.45516594e-06)
    list(1.42725e-09 0.301301214 1 6.85301643e-06)
    list(1.42925e-09 0.300085311 1 6.11256777e-06)
    list(1.43015e-09 0.299512812 0.97 2.38642386e-05)
    list(1.43175e-09 0.298502568 0.65 1.75862738e-05)
    list(1.43375e-09 0.298048925 0.25 3.50870012e-05)
    list(1.43505e-09 0.297923879 0 4.81639329e-05)
    list(1.43625e-09 0.297923866 0 2.95368572e-05)
    list(1.43825e-09 0.297923857 0 2.08274593e-05)
    list(1.44025e-09 0.29792385 0 1.96531252e-05)
    list(1.44225e-09 0.297923842 0 1.92185426e-05)
    list(1.44425e-09 0.297923835 0 1.8997604e-05)
    list(1.44625e-09 0.297923828 0 1.88760257e-05)
    list(1.44825e-09 0.297923821 0 1.8801871e-05)
    list(1.45025e-09 0.297923814 0 1.87475717e-05)
    list(1.45225e-09 0.297923808 0 1.86963712e-05)
    list(1.45425e-09 0.297923802 0 1.86363822e-05)
    list(1.45625e-09 0.297923795 0 1.85590141e-05)
    list(1.45825e-09 0.297923789 0 1.84603903e-05)
    list(1.46025e-09 0.297923783 0 1.83433608e-05)
    list(1.46225e-09 0.297923777 0 1.82168161e-05)
    list(1.46425e-09 0.29792377 0 1.80918038e-05)
    list(1.46625e-09 0.297923764 0 1.79774107e-05)
    list(1.46825e-09 0.297923758 0 1.78788411e-05)
    list(1.47025e-09 0.297923751 0 1.77976423e-05)
    list(1.47225e-09 0.297923744 0 1.77328915e-05)
    list(1.47425e-09 0.297923737 0 1.76824126e-05)
    list(1.47625e-09 0.297923731 0 1.76436453e-05)
    list(1.47825e-09 0.297923724 0 1.76141402e-05)
    list(1.48025e-09 0.297923717 0 1.75917815e-05)
    list(1.48225e-09 0.29792371 0 1.7574847e-05)
    list(1.48425e-09 0.297923704 0 1.75619867e-05)
    list(1.48625e-09 0.297923697 0 1.75521677e-05)
    list(1.48825e-09 0.29792369 0 1.75446124e-05)
    list(1.49025e-09 0.297923683 0 1.75387414e-05)
    list(1.49225e-09 0.297923677 0 1.75341259e-05)
    list(1.49425e-09 0.29792367 0 1.75304498e-05)
    list(1.49625e-09 0.297923663 0 1.75274802e-05)
    list(1.49825e-09 0.297923656 0 1.75250457e-05)
    list(1.5e-09 0.29792365 4.13590306e-14 1.75227867e-05)
    list(1.50075e-09 0.297993598 0.15 7.02786255e-06)
    list(1.50275e-09 0.298107592 0.55 -5.60524211e-06)
    list(1.50475e-09 0.297264686 0.95 2.72675524e-06)
    list(1.50535e-09 0.296853074 1 1.82349592e-05)
    list(1.50725e-09 0.295565594 1 1.20158026e-05)
    list(1.50925e-09 0.294325004 1 1.05442539e-05)
    list(1.51125e-09 0.293116796 1 9.99660105e-06)
    list(1.51325e-09 0.291918523 1 9.61746022e-06)
    list(1.51525e-09 0.290724818 1 9.27650392e-06)
    list(1.51725e-09 0.289534431 1 8.94695966e-06)
    list(1.51925e-09 0.288347074 1 8.61815702e-06)
    list(1.52125e-09 0.287162687 1 8.27778195e-06)
    list(1.52325e-09 0.285981259 1 7.90200205e-06)
    list(1.52525e-09 0.284802791 1 7.44303192e-06)
    list(1.52725e-09 0.283627287 1 6.84117448e-06)
    list(1.52925e-09 0.282454751 1 6.10087541e-06)
    list(1.53015e-09 0.281901207 0.97 2.36801923e-05)
    list(1.53175e-09 0.280890881 0.65 1.66335804e-05)
    list(1.53375e-09 0.280429394 0.25 3.6381613e-05)
    list(1.53505e-09 0.280301748 0 4.86143621e-05)
    list(1.53625e-09 0.280301736 0 2.92374549e-05)
    list(1.53825e-09 0.280301728 0 2.0739142e-05)
    list(1.54025e-09 0.280301722 0 1.96187505e-05)
    list(1.54225e-09 0.280301716 0 1.9199221e-05)
    list(1.54425e-09 0.280301709 0 1.89856467e-05)
    list(1.54625e-09 0.280301703 0 1.88678092e-05)
    list(1.54825e-09 0.280301698 0 1.87952133e-05)
    list(1.55025e-09 0.280301692 0 1.87409306e-05)
    list(1.55225e-09 0.280301687 0 1.86884643e-05)
    list(1.55425e-09 0.280301682 0 1.86260973e-05)
    list(1.55625e-09 0.280301677 0 1.85456208e-05)
    list(1.55825e-09 0.280301672 0 1.84439323e-05)
    list(1.56025e-09 0.280301667 0 1.83248125e-05)
    list(1.56225e-09 0.280301662 0 1.81977084e-05)
    list(1.56425e-09 0.280301657 0 1.8073598e-05)
    list(1.56625e-09 0.280301652 0 1.79610839e-05)
    list(1.56825e-09 0.280301647 0 1.78648149e-05)
    list(1.57025e-09 0.280301642 0 1.77859169e-05)
    list(1.57225e-09 0.280301636 0 1.77232265e-05)
    list(1.57425e-09 0.280301631 0 1.76744707e-05)
    list(1.57625e-09 0.280301626 0 1.76370814e-05)
    list(1.57825e-09 0.28030162 0 1.76086457e-05)
    list(1.58025e-09 0.280301615 0 1.75871001e-05)
    list(1.58225e-09 0.28030161 0 1.75707756e-05)
    list(1.58425e-09 0.280301604 0 1.7558369e-05)
    list(1.58625e-09 0.280301599 0 1.75488857e-05)
    list(1.58825e-09 0.280301594 0 1.75415781e-05)
    list(1.59025e-09 0.280301588 0 1.753589e-05)
    list(1.59225e-09 0.280301583 0 1.75314098e-05)
    list(1.59425e-09 0.280301578 0 1.75278341e-05)
    list(1.59625e-09 0.280301572 0 1.75249394e-05)
    list(1.59825e-09 0.280301567 0 1.75225612e-05)
    list(1.6e-09 0.280301562 0 1.75203439e-05)
    list(1.60075e-09 0.280372808 0.15 7.01369706e-06)
    list(1.60275e-09 0.280493187 0.55 -5.87701344e-06)
    list(1.60475e-09 0.279686262 0.95 3.99598173e-06)
    list(1.60535e-09 0.279300758 1 1.91881722e-05)
    list(1.60725e-09 0.278075755 1 1.21302574e-05)
    list(1.60925e-09 0.276885339 1 1.05447878e-05)
    list(1.61125e-09 0.275722699 1 9.98479173e-06)
    list(1.61325e-09 0.274568776 1 9.60439951e-06)
    list(1.61525e-09 0.273419143 1 9.26316405e-06)
    list(1.61725e-09 0.2722728 1 8.93339574e-06)
    list(1.61925e-09 0.271129525 1 8.60440123e-06)
    list(1.62125e-09 0.269989273 1 8.26389835e-06)
    list(1.62325e-09 0.268852035 1 7.88810579e-06)
    list(1.62525e-09 0.267717813 1 7.42931139e-06)
    list(1.62725e-09 0.266586608 1 6.82776485e-06)
    list(1.62925e-09 0.265458424 1 6.08763886e-06)
    list(1.63015e-09 0.264924293 0.97 2.35155699e-05)
    list(1.63175e-09 0.263916005 0.65 1.56293505e-05)
    list(1.63375e-09 0.263446297 0.25 3.78239237e-05)
    list(1.63505e-09 0.263316038 0 4.90109251e-05)
    list(1.63625e-09 0.263316026 0 2.89261013e-05)
    list(1.63825e-09 0.263316019 0 2.06621203e-05)
    list(1.64025e-09 0.263316014 0 1.95859265e-05)
    list(1.64225e-09 0.263316009 0 1.91807168e-05)
    list(1.64425e-09 0.263316004 0 1.89741071e-05)
    list(1.64625e-09 0.263315999 0 1.88597503e-05)
    list(1.64825e-09 0.263315995 0 1.87885117e-05)
    list(1.65025e-09 0.263315991 0 1.87340591e-05)
    list(1.65225e-09 0.263315987 0 1.86801387e-05)
    list(1.65425e-09 0.263315983 0 1.86152218e-05)
    list(1.65625e-09 0.263315979 0 1.85315397e-05)
    list(1.65825e-09 0.263315975 0 1.84268226e-05)
    list(1.66025e-09 0.263315971 0 1.8305774e-05)
    list(1.66225e-09 0.263315968 0 1.817832e-05)
    list(1.66425e-09 0.263315964 0 1.80552896e-05)
    list(1.66625e-09 0.26331596 0 1.79447655e-05)
    list(1.66825e-09 0.263315956 0 1.78508442e-05)
    list(1.67025e-09 0.263315952 0 1.77742502e-05)
    list(1.67225e-09 0.263315948 0 1.77135995e-05)
    list(1.67425e-09 0.263315944 0 1.76665369e-05)
    list(1.67625e-09 0.26331594 0 1.76304946e-05)
    list(1.67825e-09 0.263315936 0 1.76031004e-05)
    list(1.68025e-09 0.263315932 0 1.75823448e-05)
    list(1.68225e-09 0.263315928 0 1.7566612e-05)
    list(1.68425e-09 0.263315924 0 1.75546448e-05)
    list(1.68625e-09 0.26331592 0 1.75454863e-05)
    list(1.68825e-09 0.263315916 0 1.75384185e-05)
    list(1.69025e-09 0.263315912 0 1.75329074e-05)
    list(1.69225e-09 0.263315908 0 1.75285582e-05)
    list(1.69425e-09 0.263315904 0 1.752508e-05)
    list(1.69625e-09 0.2633159 0 1.75222583e-05)
    list(1.69825e-09 0.263315896 0 1.75199353e-05)
    list(1.7e-09 0.263315893 0 1.75177594e-05)
    list(1.70075e-09 0.263388469 0.15 6.99911385e-06)
    list(1.70275e-09 0.263514773 0.55 -6.16635013e-06)
    list(1.70475e-09 0.262747096 0.95 5.27397075e-06)
    list(1.70535e-09 0.262388147 1 2.01080998e-05)
    list(1.70725e-09 0.261225678 1 1.22281644e-05)
    list(1.70925e-09 0.260085654 1 1.05401414e-05)
    list(1.71125e-09 0.258969151 1 9.97043373e-06)
    list(1.71325e-09 0.257860301 1 9.58930237e-06)
    list(1.71525e-09 0.256755502 1 9.24791206e-06)
    list(1.71725e-09 0.255653961 1 8.91798518e-06)
    list(1.71925e-09 0.254555508 1 8.58885223e-06)
    list(1.72125e-09 0.253460108 1 8.24826909e-06)
    list(1.72325e-09 0.252367756 1 7.87250324e-06)
    list(1.72525e-09 0.25127845 1 7.41391676e-06)
    list(1.72725e-09 0.250192193 1 6.8127068e-06)
    list(1.72925e-09 0.249108985 1 6.07278284e-06)
    list(1.73015e-09 0.248594559 0.97 2.33691347e-05)
    list(1.73175e-09 0.247590491 0.65 1.4593998e-05)
    list(1.73375e-09 0.24711227 0.25 3.91592728e-05)
    list(1.73505e-09 0.246979406 0 4.9352811e-05)
    list(1.73625e-09 0.246979394 0 2.86100418e-05)
    list(1.73825e-09 0.246979389 0 2.05885208e-05)
    list(1.74025e-09 0.246979385 0 1.95597722e-05)
    list(1.74225e-09 0.246979381 0 1.91677514e-05)
    list(1.74425e-09 0.246979377 0 1.89675257e-05)
    list(1.74625e-09 0.246979373 0 1.88562354e-05)
    list(1.74825e-09 0.246979369 0 1.8786019e-05)
    list(1.75025e-09 0.246979366 0 1.87310969e-05)
    list(1.75225e-09 0.246979363 0 1.86754434e-05)
    list(1.75425e-09 0.24697936 0 1.86077403e-05)
    list(1.75625e-09 0.246979357 0 1.85207162e-05)
    list(1.75825e-09 0.246979355 0 1.84129787e-05)
    list(1.76025e-09 0.246979352 0 1.82901244e-05)
    list(1.76225e-09 0.24697935 0 1.81624697e-05)
    list(1.76425e-09 0.246979347 0 1.80406198e-05)
    list(1.76625e-09 0.246979344 0 1.79321125e-05)
    list(1.76825e-09 0.246979342 0 1.78405041e-05)
    list(1.77025e-09 0.246979339 0 1.77661423e-05)
    list(1.77225e-09 0.246979336 0 1.7707444e-05)
    list(1.77425e-09 0.246979333 0 1.76619856e-05)
    list(1.77625e-09 0.246979331 0 1.76272076e-05)
    list(1.77825e-09 0.246979328 0 1.76007814e-05)
    list(1.78025e-09 0.246979325 0 1.75807517e-05)
    list(1.78225e-09 0.246979322 0 1.75655549e-05)
    list(1.78425e-09 0.246979319 0 1.75539791e-05)
    list(1.78625e-09 0.246979317 0 1.75451036e-05)
    list(1.78825e-09 0.246979314 0 1.75382387e-05)
    list(1.79025e-09 0.246979311 0 1.75328718e-05)
    list(1.79225e-09 0.246979308 0 1.75286242e-05)
    list(1.79425e-09 0.246979306 0 1.75252167e-05)
    list(1.79625e-09 0.246979303 0 1.75224435e-05)
    list(1.79825e-09 0.2469793 0 1.75201529e-05)
    list(1.8e-09 0.246979298 4.13590306e-14 1.75179928e-05)
    list(1.80075e-09 0.247053228 0.15 6.98419678e-06)
    list(1.80275e-09 0.247185019 0.55 -6.46851075e-06)
    list(1.80475e-09 0.246459766 0.95 6.53201251e-06)
    list(1.80535e-09 0.246127513 1 2.098307e-05)
    list(1.80725e-09 0.245027058 1 1.23095347e-05)
    list(1.80925e-09 0.243937304 1 1.05311403e-05)
    list(1.81125e-09 0.242867194 1 9.95425335e-06)
    list(1.81325e-09 0.241803815 1 9.57284891e-06)
    list(1.81525e-09 0.240744277 1 9.23141842e-06)
    list(1.81725e-09 0.239687961 1 8.90139223e-06)
    list(1.81925e-09 0.238634735 1 8.57217039e-06)
    list(1.82125e-09 0.237584574 1 8.23155108e-06)
    list(1.82325e-09 0.236537472 1 7.85585232e-06)
    list(1.82525e-09 0.235493428 1 7.39750199e-06)
    list(1.82725e-09 0.234452442 1 6.79665119e-06)
    list(1.82925e-09 0.233414514 1 6.05695482e-06)
    list(1.83015e-09 0.232919941 0.97 2.32402528e-05)
    list(1.83175e-09 0.231922236 0.65 1.35513736e-05)
    list(1.83375e-09 0.231435345 0.25 4.03731508e-05)
    list(1.83505e-09 0.231299907 0 4.96407683e-05)
    list(1.83625e-09 0.231299895 0 2.82939556e-05)
    list(1.83825e-09 0.23129989 0 2.05227774e-05)
    list(1.84025e-09 0.231299888 0 1.95379804e-05)
    list(1.84225e-09 0.231299884 0 1.91582577e-05)
    list(1.84425e-09 0.231299881 0 1.89638938e-05)
    list(1.84625e-09 0.231299878 0 1.88552851e-05)
    list(1.84825e-09 0.231299876 0 1.87857743e-05)
    list(1.85025e-09 0.231299874 0 1.87300976e-05)
    list(1.85225e-09 0.231299872 0 1.86724489e-05)
    list(1.85425e-09 0.23129987 0 1.86017487e-05)
    list(1.85625e-09 0.231299868 0 1.85112819e-05)
    list(1.85825e-09 0.231299867 0 1.84005685e-05)
    list(1.86025e-09 0.231299865 0 1.82760544e-05)
    list(1.86225e-09 0.231299863 0 1.81483539e-05)
    list(1.86425e-09 0.231299862 0 1.80277803e-05)
    list(1.86625e-09 0.23129986 0 1.79213098e-05)
    list(1.86825e-09 0.231299859 0 1.78319753e-05)
    list(1.87025e-09 0.231299857 0 1.77597728e-05)
    list(1.87225e-09 0.231299855 0 1.77029415e-05)
    list(1.87425e-09 0.231299854 0 1.76590029e-05)
    list(1.87625e-09 0.231299852 0 1.76254123e-05)
    list(1.87825e-09 0.23129985 0 1.75998871e-05)
    list(1.88025e-09 0.231299849 0 1.75805263e-05)
    list(1.88225e-09 0.231299847 0 1.75658177e-05)
    list(1.88425e-09 0.231299846 0 1.75545928e-05)
    list(1.88625e-09 0.231299844 0 1.75459661e-05)
    list(1.88825e-09 0.231299842 0 1.75392749e-05)
    list(1.89025e-09 0.231299841 0 1.7534027e-05)
    list(1.89225e-09 0.231299839 0 1.7529859e-05)
    list(1.89425e-09 0.231299838 0 1.75265029e-05)
    list(1.89625e-09 0.231299836 0 1.75237609e-05)
    list(1.89825e-09 0.231299835 0 1.75214873e-05)
    list(1.9e-09 0.231299833 0 1.75193258e-05)
    list(1.90075e-09 0.231375129 0.15 6.96898476e-06)
    list(1.90275e-09 0.231511997 0.55 -6.78001799e-06)
    list(1.90475e-09 0.230832156 0.95 7.74674475e-06)
    list(1.90535e-09 0.230526463 1 2.18042556e-05)
    list(1.90725e-09 0.229487 1 1.23741458e-05)
    list(1.90925e-09 0.228447109 1 1.05180434e-05)
    list(1.91125e-09 0.227423376 1 9.93633191e-06)
    list(1.91325e-09 0.226405574 1 9.55506924e-06)
    list(1.91525e-09 0.225391431 1 9.21371629e-06)
    list(1.91725e-09 0.224380467 1 8.88366647e-06)
    list(1.91925e-09 0.223372581 1 8.55442077e-06)
    list(1.92125e-09 0.222367752 1 8.2138227e-06)
    list(1.92325e-09 0.221365977 1 7.83823871e-06)
    list(1.92525e-09 0.220367253 1 7.3801643e-06)
    list(1.92725e-09 0.219371579 1 6.77970497e-06)
    list(1.92925e-09 0.218378954 1 6.04026913e-06)
    list(1.93015e-09 0.21790425 0.97 2.31281171e-05)
    list(1.93175e-09 0.216914934 0.65 1.25273797e-05)
    list(1.93375e-09 0.216419367 0.25 4.14710931e-05)
    list(1.93505e-09 0.216281405 0 4.98704997e-05)
    list(1.93625e-09 0.216281394 0 2.79819553e-05)
    list(1.93825e-09 0.21628139 0 2.04643875e-05)
    list(1.94025e-09 0.216281388 0 1.95195919e-05)
    list(1.94225e-09 0.216281385 0 1.91510336e-05)
    list(1.94425e-09 0.216281383 0 1.89619099e-05)
    list(1.94625e-09 0.216281381 0 1.88555711e-05)
    list(1.94825e-09 0.216281379 0 1.87864573e-05)
    list(1.95025e-09 0.216281378 0 1.87297695e-05)
    list(1.95225e-09 0.216281377 0 1.86699077e-05)
    list(1.95425e-09 0.216281376 0 1.859606e-05)
    list(1.95625e-09 0.216281375 0 1.85021206e-05)
    list(1.95825e-09 0.216281375 0 1.83885388e-05)
    list(1.96025e-09 0.216281374 0 1.82625479e-05)
    list(1.96225e-09 0.216281373 0 1.81349661e-05)
    list(1.96425e-09 0.216281373 0 1.80157568e-05)
    list(1.96625e-09 0.216281372 0 1.79113293e-05)
    list(1.96825e-09 0.216281372 0 1.78242165e-05)
    list(1.97025e-09 0.216281371 0 1.77540914e-05)
    list(1.97225e-09 0.21628137 0 1.7699037e-05)
    list(1.97425e-09 0.21628137 0 1.76565327e-05)
    list(1.97625e-09 0.216281369 0 1.76240542e-05)
    list(1.97825e-09 0.216281369 0 1.75993666e-05)
    list(1.98025e-09 0.216281368 0 1.75806226e-05)
    list(1.98225e-09 0.216281367 0 1.75663597e-05)
    list(1.98425e-09 0.216281367 0 1.75554515e-05)
    list(1.98625e-09 0.216281366 0 1.75470457e-05)
    list(1.98825e-09 0.216281366 0 1.75405053e-05)
    list(1.99025e-09 0.216281365 0 1.75353576e-05)
    list(1.99225e-09 0.216281365 0 1.75312535e-05)
    list(1.99425e-09 0.216281365 0 1.75279353e-05)
    list(1.99625e-09 0.216281364 0 1.75252132e-05)
    list(1.99825e-09 0.216281364 0 1.75229467e-05)
    list(2e-09 0.216281363 0 1.75207739e-05)
    list(2.00075e-09 0.216358027 0.15 6.95356333e-06)
    list(2.00275e-09 0.216499601 0.55 -7.09500337e-06)
    list(2.00475e-09 0.215867909 0.95 8.9013386e-06)
    list(2.00535e-09 0.215588399 1 2.25669364e-05)
    list(2.00725e-09 0.214608558 1 1.24227295e-05)
    list(2.00925e-09 0.213617891 1 1.05010592e-05)
    list(2.01125e-09 0.212640279 1 9.91670333e-06)
    list(2.01325e-09 0.211667912 1 9.53599313e-06)
    list(2.01525e-09 0.210699041 1 9.1948665e-06)
    list(2.01725e-09 0.209733299 1 8.86490196e-06)
    list(2.01925e-09 0.208770609 1 8.53572745e-06)
    list(2.02125e-09 0.207810956 1 8.19523427e-06)
    list(2.02325e-09 0.206854335 1 7.81983722e-06)
    list(2.02525e-09 0.205900742 1 7.36209888e-06)
    list(2.02725e-09 0.204950178 1 6.76208177e-06)
    list(2.02925e-09 0.204002638 1 6.02295489e-06)
    list(2.03015e-09 0.20354771 0.97 2.3032105e-05)
    list(2.03175e-09 0.202568637 0.65 1.15490923e-05)
    list(2.03375e-09 0.202064562 0.25 4.24641406e-05)
    list(2.03505e-09 0.201924145 0 5.00447671e-05)
    list(2.03625e-09 0.201924133 0 2.76771876e-05)
    list(2.03825e-09 0.20192413 0 2.04121032e-05)
    list(2.04025e-09 0.201924129 0 1.95038838e-05)
    list(2.04225e-09 0.201924127 0 1.91455798e-05)
    list(2.04425e-09 0.201924125 0 1.89611875e-05)
    list(2.04625e-09 0.201924124 0 1.88567736e-05)
    list(2.04825e-09 0.201924123 0 1.87877943e-05)
    list(2.05025e-09 0.201924123 0 1.8729876e-05)
    list(2.05225e-09 0.201924122 0 1.86676214e-05)
    list(2.05425e-09 0.201924122 0 1.85905196e-05)
    list(2.05625e-09 0.201924122 0 1.84931242e-05)
    list(2.05825e-09 0.201924123 0 1.83768172e-05)
    list(2.06025e-09 0.201924123 0 1.82495475e-05)
    list(2.06225e-09 0.201924123 0 1.8122246e-05)
    list(2.06425e-09 0.201924124 0 1.80044788e-05)
    list(2.06625e-09 0.201924124 0 1.79020908e-05)
    list(2.06825e-09 0.201924124 0 1.78171419e-05)
    list(2.07025e-09 0.201924124 0 1.77490109e-05)
    list(2.07225e-09 0.201924125 0 1.76956447e-05)
    list(2.07425e-09 0.201924125 0 1.76544921e-05)
    list(2.07625e-09 0.201924125 0 1.76230547e-05)
    list(2.07825e-09 0.201924126 0 1.75991458e-05)
    list(2.08025e-09 0.201924126 0 1.75809711e-05)
    list(2.08225e-09 0.201924127 0 1.75671162e-05)
    list(2.08425e-09 0.201924127 0 1.75564945e-05)
    list(2.08625e-09 0.201924127 0 1.75482856e-05)
    list(2.08825e-09 0.201924128 0 1.7541877e-05)
    list(2.09025e-09 0.201924128 0 1.75368141e-05)
    list(2.09225e-09 0.201924129 0 1.75327613e-05)
    list(2.09425e-09 0.20192413 0 1.75294708e-05)
    list(2.09625e-09 0.20192413 0 1.75267599e-05)
    list(2.09825e-09 0.201924131 0 1.75244933e-05)
    list(2.1e-09 0.201924131 0 1.7522302e-05)
    list(2.10075e-09 0.202002154 0.15 6.9380083e-06)
    list(2.10275e-09 0.202148112 0.55 -7.40696477e-06)
    list(2.10475e-09 0.201566998 0.95 9.98438413e-06)
    list(2.10535e-09 0.201313073 1 2.32691339e-05)
    list(2.10725e-09 0.200391129 1 1.24564368e-05)
    list(2.10925e-09 0.199448865 1 1.04813734e-05)
    list(2.11125e-09 0.198516919 1 9.89627146e-06)
    list(2.11325e-09 0.197589631 1 9.51637611e-06)
    list(2.11525e-09 0.196665692 1 9.17553345e-06)
    list(2.11725e-09 0.195744826 1 8.84568954e-06)
    list(2.11925e-09 0.194826976 1 8.51661751e-06)
    list(2.12125e-09 0.193912128 1 8.17625695e-06)
    list(2.12325e-09 0.193000278 1 7.80107022e-06)
    list(2.12525e-09 0.192091423 1 7.34368601e-06)
    list(2.12725e-09 0.19118556 1 6.7441255e-06)
    list(2.12925e-09 0.190282687 1 6.00532304e-06)
    list(2.13015e-09 0.189847348 0.97 2.29514403e-05)
    list(2.13175e-09 0.188880168 0.65 1.06369937e-05)
    list(2.13375e-09 0.188367923 0.25 4.33627765e-05)
    list(2.13505e-09 0.188225133 0 5.01657681e-05)
    list(2.13625e-09 0.188225121 0 2.73825667e-05)
    list(2.13825e-09 0.188225119 0 2.03653361e-05)
    list(2.14025e-09 0.188225118 0 1.94904602e-05)
    list(2.14225e-09 0.188225117 0 1.91415485e-05)
    list(2.14425e-09 0.188225116 0 1.8961408e-05)
    list(2.14625e-09 0.188225116 0 1.88586004e-05)
    list(2.14825e-09 0.188225115 0 1.87895197e-05)
    list(2.15025e-09 0.188225115 0 1.87301823e-05)
    list(2.15225e-09 0.188225116 0 1.8665393e-05)
    list(2.15425e-09 0.188225116 0 1.85849774e-05)
    list(2.15625e-09 0.188225117 0 1.84841905e-05)
    list(2.15825e-09 0.188225118 0 1.8365335e-05)
    list(2.16025e-09 0.188225119 0 1.82369948e-05)
    list(2.16225e-09 0.18822512 0 1.81101273e-05)
    list(2.16425e-09 0.188225122 0 1.79938656e-05)
    list(2.16625e-09 0.188225123 0 1.78935009e-05)
    list(2.16825e-09 0.188225124 0 1.781065e-05)
    list(2.17025e-09 0.188225125 0 1.77444258e-05)
    list(2.17225e-09 0.188225126 0 1.76926591e-05)
    list(2.17425e-09 0.188225127 0 1.76527784e-05)
    list(2.17625e-09 0.188225128 0 1.76223147e-05)
    list(2.17825e-09 0.18822513 0 1.75991302e-05)
    list(2.18025e-09 0.188225131 0 1.75814821e-05)
    list(2.18225e-09 0.188225132 0 1.75680021e-05)
    list(2.18425e-09 0.188225133 0 1.75576417e-05)
    list(2.18625e-09 0.188225135 0 1.75496106e-05)
    list(2.18825e-09 0.188225136 0 1.75433191e-05)
    list(2.19025e-09 0.188225137 0 1.75383299e-05)
    list(2.19225e-09 0.188225139 0 1.75343199e-05)
    list(2.19425e-09 0.18822514 0 1.75310505e-05)
    list(2.19625e-09 0.188225142 0 1.75283458e-05)
    list(2.19825e-09 0.188225143 0 1.75260752e-05)
    list(2.2e-09 0.188225144 0 1.75238622e-05)
    list(2.20075e-09 0.188304506 0.15 6.92236286e-06)
    list(2.20275e-09 0.188454582 0.55 -7.70648615e-06)
    list(2.20475e-09 0.187926109 0.95 1.09918796e-05)
    list(2.20535e-09 0.187696991 1 2.39104238e-05)
    list(2.20725e-09 0.18683107 1 1.24766515e-05)
    list(2.20925e-09 0.185936255 1 1.04592229e-05)
    list(2.21125e-09 0.185049363 1 9.87497554e-06)
    list(2.21325e-09 0.184166621 1 9.49613347e-06)
    list(2.21525e-09 0.183287095 1 9.15565166e-06)
    list(2.21725e-09 0.182410581 1 8.82598724e-06)
    list(2.21925e-09 0.181537036 1 8.49706982e-06)
    list(2.22125e-09 0.180666451 1 8.15688755e-06)
    list(2.22325e-09 0.179798819 1 7.78195029e-06)
    list(2.22525e-09 0.178934138 1 7.32495278e-06)
    list(2.22725e-09 0.178072405 1 6.72587647e-06)
    list(2.22925e-09 0.177213617 1 5.98742453e-06)
    list(2.23015e-09 0.176797611 0.97 2.28850417e-05)
    list(2.23175e-09 0.175843731 0.65 9.80469246e-06)
    list(2.23375e-09 0.175323821 0.25 4.41874329e-05)
    list(2.23505e-09 0.175178752 0 5.0235936e-05)
    list(2.23625e-09 0.175178741 0 2.7099859e-05)
    list(2.23825e-09 0.175178739 0 2.03230753e-05)
    list(2.24025e-09 0.175178739 0 1.94786333e-05)
    list(2.24225e-09 0.175178738 0 1.91383648e-05)
    list(2.24425e-09 0.175178738 0 1.896208e-05)
    list(2.24625e-09 0.175178738 0 1.88606314e-05)
    list(2.24825e-09 0.175178738 0 1.8791278e-05)
    list(2.25025e-09 0.175178739 0 1.87303949e-05)
    list(2.25225e-09 0.17517874 0 1.86629932e-05)
    list(2.25425e-09 0.175178741 0 1.85792712e-05)
    list(2.25625e-09 0.175178743 0 1.84752184e-05)
    list(2.25825e-09 0.175178744 0 1.83540313e-05)
    list(2.26025e-09 0.175178746 0 1.82248433e-05)
    list(2.26225e-09 0.175178748 0 1.80985615e-05)
    list(2.26425e-09 0.175178749 0 1.79838609e-05)
    list(2.26625e-09 0.175178751 0 1.7885497e-05)
    list(2.26825e-09 0.175178753 0 1.78046761e-05)
    list(2.27025e-09 0.175178755 0 1.77402733e-05)
    list(2.27225e-09 0.175178757 0 1.76900213e-05)
    list(2.27425e-09 0.175178759 0 1.76513375e-05)
    list(2.27625e-09 0.175178761 0 1.76217856e-05)
    list(2.27825e-09 0.175178762 0 1.75992765e-05)
    list(2.28025e-09 0.175178764 0 1.75821173e-05)
    list(2.28225e-09 0.175178767 0 1.75689836e-05)
    list(2.28425e-09 0.175178769 0 1.75588633e-05)
    list(2.28625e-09 0.175178771 0 1.75509942e-05)
    list(2.28825e-09 0.175178773 0 1.75448082e-05)
    list(2.29025e-09 0.175178775 0 1.75398841e-05)
    list(2.29225e-09 0.175178777 0 1.75359105e-05)
    list(2.29425e-09 0.175178779 0 1.75326577e-05)
    list(2.29625e-09 0.175178781 0 1.75299557e-05)
    list(2.29825e-09 0.175178784 0 1.75276785e-05)
    list(2.3e-09 0.175178786 8.27180613e-14 1.75254419e-05)
    list(2.30075e-09 0.175259458 0.15 6.90666909e-06)
    list(2.30275e-09 0.175413447 0.55 -7.98000395e-06)
    list(2.30475e-09 0.174939263 0.95 1.19273116e-05)
    list(2.30535e-09 0.174734034 1 2.44915543e-05)
    list(2.30725e-09 0.173922151 1 1.24849177e-05)
    list(2.30925e-09 0.173073733 1 1.04350876e-05)
    list(2.31125e-09 0.172231151 1 9.85309435e-06)
    list(2.31325e-09 0.171392287 1 9.47550229e-06)
    list(2.31525e-09 0.170556513 1 9.13545301e-06)
    list(2.31725e-09 0.169723687 1 8.8060257e-06)
    list(2.31925e-09 0.168893778 1 8.47731344e-06)
    list(2.32125e-09 0.168066776 1 8.137353e-06)
    list(2.32325e-09 0.167242678 1 7.76270214e-06)
    list(2.32525e-09 0.16642148 1 7.30612232e-06)
    list(2.32725e-09 0.165603177 1 6.70755672e-06)
    list(2.32925e-09 0.164787767 1 5.96947887e-06)
    list(2.33015e-09 0.164390785 0.97 2.28313891e-05)
    list(2.33175e-09 0.163451407 0.65 9.0629187e-06)
    list(2.33375e-09 0.162924504 0.25 4.49504134e-05)
    list(2.33505e-09 0.162777261 0 5.02592352e-05)
    list(2.33625e-09 0.16277725 0 2.68307416e-05)
    list(2.33825e-09 0.162777249 0 2.02835324e-05)
    list(2.34025e-09 0.162777249 0 1.94667738e-05)
    list(2.34225e-09 0.162777248 0 1.91344597e-05)
    list(2.34425e-09 0.162777248 0 1.89616737e-05)
    list(2.34625e-09 0.162777249 0 1.88613712e-05)
    list(2.34825e-09 0.162777249 0 1.87916077e-05)
    list(2.35025e-09 0.162777251 0 1.872909e-05)
    list(2.35225e-09 0.162777252 0 1.86590425e-05)
    list(2.35425e-09 0.162777254 0 1.85720701e-05)
    list(2.35625e-09 0.162777256 0 1.84649192e-05)
    list(2.35825e-09 0.162777258 0 1.83416401e-05)
    list(2.36025e-09 0.16277726 0 1.82118279e-05)
    list(2.36225e-09 0.162777262 0 1.80862723e-05)
    list(2.36425e-09 0.162777265 0 1.79731765e-05)
    list(2.36625e-09 0.162777267 0 1.7876784e-05)
    list(2.36825e-09 0.16277727 0 1.77979236e-05)
    list(2.37025e-09 0.162777272 0 1.773526e-05)
    list(2.37225e-09 0.162777274 0 1.76864442e-05)
    list(2.37425e-09 0.162777277 0 1.76488903e-05)
    list(2.37625e-09 0.162777279 0 1.76201971e-05)
    list(2.37825e-09 0.162777282 0 1.75983237e-05)
    list(2.38025e-09 0.162777285 0 1.75816248e-05)
    list(2.38225e-09 0.162777287 0 1.75688181e-05)
    list(2.38425e-09 0.16277729 0 1.75589253e-05)
    list(2.38625e-09 0.162777293 0 1.75512109e-05)
    list(2.38825e-09 0.162777295 0 1.7545127e-05)
    list(2.39025e-09 0.162777298 0 1.75402673e-05)
    list(2.39225e-09 0.162777301 0 1.75363316e-05)
    list(2.39425e-09 0.162777304 0 1.75330981e-05)
    list(2.39625e-09 0.162777307 0 1.75304024e-05)
    list(2.39825e-09 0.16277731 0 1.75281229e-05)
    list(2.4e-09 0.162777312 0 1.75258691e-05)
    list(2.40075e-09 0.162859257 0.15 6.89098465e-06)
    list(2.40275e-09 0.163017026 0.55 -8.2218305e-06)
    list(2.40475e-09 0.162598326 0.95 1.27903094e-05)
    list(2.40535e-09 0.162415969 1 2.5014553e-05)
    list(2.40725e-09 0.161656092 1 1.24831401e-05)
    list(2.40925e-09 0.160852956 1 1.04097889e-05)
    list(2.41125e-09 0.160053852 1 9.8310685e-06)
    list(2.41325e-09 0.15925809 1 9.45481879e-06)
    list(2.41525e-09 0.158465304 1 9.11522049e-06)
    list(2.41725e-09 0.157675401 1 8.7860473e-06)
    list(2.41925e-09 0.156888357 1 8.45755653e-06)
    list(2.42125e-09 0.156104164 1 8.1178325e-06)
    list(2.42325e-09 0.155322819 1 7.74348096e-06)
    list(2.42525e-09 0.154544318 1 7.28733078e-06)
    list(2.42725e-09 0.153768656 1 6.68928746e-06)
    list(2.42925e-09 0.15299583 1 5.95159413e-06)
    list(2.43015e-09 0.152617527 0.97 2.27885441e-05)
    list(2.43175e-09 0.151693656 0.65 8.41464003e-06)
    list(2.43375e-09 0.15116058 0.25 4.56588768e-05)
    list(2.43505e-09 0.151011272 0 5.02406753e-05)
    list(2.43625e-09 0.151011261 0 2.65766013e-05)
    list(2.43825e-09 0.15101126 0 2.02455326e-05)
    list(2.44025e-09 0.15101126 0 1.94539365e-05)
    list(2.44225e-09 0.15101126 0 1.91289274e-05)
    list(2.44425e-09 0.151011261 0 1.89593069e-05)
    list(2.44625e-09 0.151011261 0 1.88599583e-05)
    list(2.44825e-09 0.151011262 0 1.87896699e-05)
    list(2.45025e-09 0.151011264 0 1.87254559e-05)
    list(2.45225e-09 0.151011266 0 1.8652763e-05)
    list(2.45425e-09 0.151011268 0 1.85626333e-05)
    list(2.45625e-09 0.15101127 0 1.845258e-05)
    list(2.45825e-09 0.151011273 0 1.83274556e-05)
    list(2.46025e-09 0.151011275 0 1.81972309e-05)
    list(2.46225e-09 0.151011278 0 1.8072522e-05)
    list(2.46425e-09 0.151011281 0 1.79610566e-05)
    list(2.46625e-09 0.151011284 0 1.78665939e-05)
    list(2.46825e-09 0.151011287 0 1.7789619e-05)
    list(2.47025e-09 0.151011289 0 1.77286114e-05)
    list(2.47225e-09 0.151011292 0 1.76811555e-05)
    list(2.47425e-09 0.151011295 0 1.76446687e-05)
    list(2.47625e-09 0.151011298 0 1.7616786e-05)
    list(2.47825e-09 0.151011302 0 1.75955136e-05)
    list(2.48025e-09 0.151011305 0 1.75792518e-05)
    list(2.48225e-09 0.151011308 0 1.75667577e-05)
    list(2.48425e-09 0.151011311 0 1.7557085e-05)
    list(2.48625e-09 0.151011314 0 1.75495231e-05)
    list(2.48825e-09 0.151011318 0 1.75435426e-05)
    list(2.49025e-09 0.151011321 0 1.75387513e-05)
    list(2.49225e-09 0.151011324 0 1.75348592e-05)
    list(2.49425e-09 0.151011327 0 1.75316519e-05)
    list(2.49625e-09 0.151011331 0 1.75289704e-05)
    list(2.49825e-09 0.151011334 0 1.75266969e-05)
    list(2.5e-09 0.151011337 0 1.75244372e-05)
    list(2.50075e-09 0.151094509 0.15 6.87535249e-06)
    list(2.50275e-09 0.151256001 0.55 -8.42110453e-06)
    list(2.50475e-09 0.150893494 0.95 1.35871887e-05)
    list(2.50535e-09 0.150732929 1 2.54816089e-05)
    list(2.50725e-09 0.150023024 1 1.24730013e-05)
    list(2.50925e-09 0.149264022 1 1.0383853e-05)
    list(2.51125e-09 0.148507498 1 9.80918743e-06)
    list(2.51325e-09 0.147753996 1 9.4343307e-06)
    list(2.51525e-09 0.147003366 1 9.09519085e-06)
    list(2.51725e-09 0.14625555 1 8.76628181e-06)
    list(2.51925e-09 0.145510534 1 8.43802247e-06)
    list(2.52125e-09 0.144768311 1 8.09854345e-06)
    list(2.52325e-09 0.144028877 1 7.72449902e-06)
    list(2.52525e-09 0.143292227 1 7.26878666e-06)
    list(2.52725e-09 0.142558358 1 6.67127464e-06)
    list(2.52925e-09 0.141827266 1 5.93397262e-06)
    list(2.53015e-09 0.141467278 0.97 2.27543052e-05)
    list(2.53175e-09 0.140559751 0.65 7.85818576e-06)
    list(2.53375e-09 0.140021438 0.25 4.63164346e-05)
    list(2.53505e-09 0.13987018 0 5.01859977e-05)
    list(2.53625e-09 0.139870169 0 2.63385013e-05)
    list(2.53825e-09 0.139870168 0 2.02109581e-05)
    list(2.54025e-09 0.139870169 0 1.94421848e-05)
    list(2.54225e-09 0.139870169 0 1.91238654e-05)
    list(2.54425e-09 0.139870169 0 1.89570978e-05)
    list(2.54625e-09 0.13987017 0 1.88585291e-05)
    list(2.54825e-09 0.139870171 0 1.87876194e-05)
    list(2.55025e-09 0.139870173 0 1.87216692e-05)
    list(2.55225e-09 0.139870175 0 1.86463574e-05)
    list(2.55425e-09 0.139870178 0 1.85531887e-05)
    list(2.55625e-09 0.13987018 0 1.84404408e-05)
    list(2.55825e-09 0.139870183 0 1.83137083e-05)
    list(2.56025e-09 0.139870186 0 1.81832562e-05)
    list(2.56225e-09 0.139870189 0 1.80594819e-05)
    list(2.56425e-09 0.139870192 0 1.79496429e-05)
    list(2.56625e-09 0.139870195 0 1.78570456e-05)
    list(2.56825e-09 0.139870198 0 1.77818642e-05)
    list(2.57025e-09 0.139870202 0 1.7722417e-05)
    list(2.57225e-09 0.139870205 0 1.76762347e-05)
    list(2.57425e-09 0.139870208 0 1.76407432e-05)
    list(2.57625e-09 0.139870212 0 1.76136148e-05)
    list(2.57825e-09 0.139870215 0 1.75929008e-05)
    list(2.58025e-09 0.139870219 0 1.75770449e-05)
    list(2.58225e-09 0.139870222 0 1.75648412e-05)
    list(2.58425e-09 0.139870226 0 1.75553731e-05)
    list(2.58625e-09 0.13987023 0 1.7547953e-05)
    list(2.58825e-09 0.139870233 0 1.75420691e-05)
    list(2.59025e-09 0.139870237 0 1.7537342e-05)
    list(2.59225e-09 0.139870241 0 1.75334911e-05)
    list(2.59425e-09 0.139870245 0 1.75303089e-05)
    list(2.59625e-09 0.139870248 0 1.75276414e-05)
    list(2.59825e-09 0.139870252 0 1.75253742e-05)
    list(2.6e-09 0.139870256 0 1.75231098e-05)
    list(2.60075e-09 0.139954603 0.15 6.8598054e-06)
    list(2.60275e-09 0.140119831 0.55 -8.56824933e-06)
    list(2.60475e-09 0.139813736 0.95 1.43241315e-05)
    list(2.60535e-09 0.139673859 1 2.5895247e-05)
    list(2.60725e-09 0.139011921 1 1.24559858e-05)
    list(2.60925e-09 0.138295893 1 1.0357723e-05)
    list(2.61125e-09 0.137581019 1 9.78758221e-06)
    list(2.61325e-09 0.136868895 1 9.41411195e-06)
    list(2.61525e-09 0.136159545 1 9.07541961e-06)
    list(2.61725e-09 0.135452943 1 8.7467725e-06)
    list(2.61925e-09 0.134749079 1 8.41874452e-06)
    list(2.62125e-09 0.134047948 1 8.07951103e-06)
    list(2.62325e-09 0.133349546 1 7.70577546e-06)
    list(2.62525e-09 0.132653868 1 7.25050568e-06)
    list(2.62725e-09 0.13196091 1 6.65353229e-06)
    list(2.62925e-09 0.131270669 1 5.91662673e-06)
    list(2.63015e-09 0.130928622 0.97 2.27264344e-05)
    list(2.63175e-09 0.13003813 0.65 7.3887516e-06)
    list(2.63375e-09 0.129495589 0.25 4.70706319e-05)
    list(2.63505e-09 0.129342499 0 5.00968452e-05)
    list(2.63625e-09 0.129342488 0 2.61102762e-05)
    list(2.63825e-09 0.129342487 0 2.01730652e-05)
    list(2.64025e-09 0.129342488 0 1.94262361e-05)
    list(2.64225e-09 0.129342488 0 1.91149824e-05)
    list(2.64425e-09 0.129342489 0 1.89515191e-05)
    list(2.64625e-09 0.129342489 0 1.88541752e-05)
    list(2.64825e-09 0.129342491 0 1.87830634e-05)
    list(2.65025e-09 0.129342493 0 1.87157746e-05)
    list(2.65225e-09 0.129342495 0 1.86382445e-05)
    list(2.65425e-09 0.129342498 0 1.85424712e-05)
    list(2.65625e-09 0.1293425 0 1.8427494e-05)
    list(2.65825e-09 0.129342503 0 1.82995923e-05)
    list(2.66025e-09 0.129342507 0 1.81692563e-05)
    list(2.66225e-09 0.12934251 0 1.80466357e-05)
    list(2.66425e-09 0.129342513 0 1.79385328e-05)
    list(2.66625e-09 0.129342517 0 1.78478363e-05)
    list(2.66825e-09 0.12934252 0 1.77744437e-05)
    list(2.67025e-09 0.129342524 0 1.77165357e-05)
    list(2.67225e-09 0.129342527 0 1.76716031e-05)
    list(2.67425e-09 0.129342531 0 1.76370866e-05)
    list(2.67625e-09 0.129342535 0 1.76106971e-05)
    list(2.67825e-09 0.129342538 0 1.75905311e-05)
    list(2.68025e-09 0.129342542 0 1.75750744e-05)
    list(2.68225e-09 0.129342546 0 1.75631567e-05)
    list(2.68425e-09 0.12934255 0 1.75538902e-05)
    list(2.68625e-09 0.129342554 0 1.75466095e-05)
    list(2.68825e-09 0.129342558 0 1.75408195e-05)
    list(2.69025e-09 0.129342562 0 1.75361533e-05)
    list(2.69225e-09 0.129342566 0 1.75323397e-05)
    list(2.69425e-09 0.12934257 0 1.75291778e-05)
    list(2.69625e-09 0.129342574 0 1.75265186e-05)
    list(2.69825e-09 0.129342578 0 1.75242514e-05)
    list(2.7e-09 0.129342582 0 1.75219738e-05)
    list(2.70075e-09 0.129428048 0.15 6.84440666e-06)
    list(2.70275e-09 0.129597097 0.55 -8.6553258e-06)
    list(2.70475e-09 0.129347161 0.95 1.50058867e-05)
    list(2.70535e-09 0.129226867 1 2.62560858e-05)
    list(2.70725e-09 0.128610936 1 1.24337842e-05)
    list(2.70925e-09 0.127936714 1 1.03317227e-05)
    list(2.71125e-09 0.12726254 1 9.76659033e-06)
    list(2.71325e-09 0.126590887 1 9.39446985e-06)
    list(2.71525e-09 0.125921918 1 9.05618564e-06)
    list(2.71725e-09 0.125255632 1 8.72777285e-06)
    list(2.71925e-09 0.124592022 1 8.39995392e-06)
    list(2.72125e-09 0.123931084 1 8.06094724e-06)
    list(2.72325e-09 0.123272812 1 7.68750607e-06)
    list(2.72525e-09 0.122617204 1 7.23267053e-06)
    list(2.72725e-09 0.121964254 1 6.63623297e-06)
    list(2.72925e-09 0.12131396 1 5.89971947e-06)
    list(2.73015e-09 0.120989474 0.97 2.27028656e-05)
    list(2.73175e-09 0.120116582 0.65 6.99958199e-06)
    list(2.73375e-09 0.11957088 0.25 4.77991279e-05)
    list(2.73505e-09 0.119416075 0 4.99768168e-05)
    list(2.73625e-09 0.119416063 0 2.58980539e-05)
    list(2.73825e-09 0.119416063 0 2.01384106e-05)
    list(2.74025e-09 0.119416063 0 1.94111569e-05)
    list(2.74225e-09 0.119416063 0 1.91062577e-05)
    list(2.74425e-09 0.119416063 0 1.89457728e-05)
    list(2.74625e-09 0.119416064 0 1.88495087e-05)
    list(2.74825e-09 0.119416066 0 1.87781508e-05)
    list(2.75025e-09 0.119416068 0 1.87095519e-05)
    list(2.75225e-09 0.11941607 0 1.8629908e-05)
    list(2.75425e-09 0.119416073 0 1.85317188e-05)
    list(2.75625e-09 0.119416076 0 1.84147583e-05)
    list(2.75825e-09 0.119416079 0 1.82859202e-05)
    list(2.76025e-09 0.119416082 0 1.8155852e-05)
    list(2.76225e-09 0.119416085 0 1.80344339e-05)
    list(2.76425e-09 0.119416089 0 1.79280326e-05)
    list(2.76625e-09 0.119416092 0 1.78391545e-05)
    list(2.76825e-09 0.119416096 0 1.77674516e-05)
    list(2.77025e-09 0.1194161 0 1.77109871e-05)
    list(2.77225e-09 0.119416104 0 1.76672217e-05)
    list(2.77425e-09 0.119416107 0 1.7633614e-05)
    list(2.77625e-09 0.119416111 0 1.76079134e-05)
    list(2.77825e-09 0.119416115 0 1.75882587e-05)
    list(2.78025e-09 0.119416119 0 1.75731755e-05)
    list(2.78225e-09 0.119416123 0 1.75615266e-05)
    list(2.78425e-09 0.119416127 0 1.75524507e-05)
    list(2.78625e-09 0.119416132 0 1.75453028e-05)
    list(2.78825e-09 0.119416136 0 1.75396034e-05)
    list(2.79025e-09 0.11941614 0 1.75349971e-05)
    list(2.79225e-09 0.119416144 0 1.75312212e-05)
    list(2.79425e-09 0.119416149 0 1.75280811e-05)
    list(2.79625e-09 0.119416153 0 1.75254324e-05)
    list(2.79825e-09 0.119416157 0 1.75231675e-05)
    list(2.8e-09 0.119416161 0 1.75208805e-05)
    list(2.80075e-09 0.119502686 0.15 6.82916412e-06)
    list(2.80275e-09 0.119675685 0.55 -8.68013924e-06)
    list(2.80475e-09 0.119481198 0.95 1.56345223e-05)
    list(2.80535e-09 0.119379396 1 2.65721659e-05)
    list(2.80725e-09 0.118807551 1 1.24071725e-05)
    list(2.80925e-09 0.11817398 1 1.03060694e-05)
    list(2.81125e-09 0.117539542 1 9.74607115e-06)
    list(2.81325e-09 0.116907434 1 9.37525199e-06)
    list(2.81525e-09 0.116277927 1 9.03736131e-06)
    list(2.81725e-09 0.115651036 1 8.70918027e-06)
    list(2.81925e-09 0.115026758 1 8.38157012e-06)
    list(2.82125e-09 0.114405088 1 8.04279089e-06)
    list(2.82325e-09 0.113786023 1 7.66964698e-06)
    list(2.82525e-09 0.113169557 1 7.21525332e-06)
    list(2.82725e-09 0.112555686 1 6.61936347e-06)
    list(2.82925e-09 0.111944406 1 5.88324999e-06)
    list(2.83015e-09 0.111637091 0.97 2.26819467e-05)
    list(2.83175e-09 0.110782241 0.65 6.67607338e-06)
    list(2.83375e-09 0.110234452 0.25 4.85037847e-05)
    list(2.83505e-09 0.110078047 0 4.9837233e-05)
    list(2.83625e-09 0.110078035 0 2.57013147e-05)
    list(2.83825e-09 0.110078035 0 2.01057823e-05)
    list(2.84025e-09 0.110078035 0 1.93963798e-05)
    list(2.84225e-09 0.110078035 0 1.90973959e-05)
    list(2.84425e-09 0.110078035 0 1.89396963e-05)
    list(2.84625e-09 0.110078036 0 1.88444371e-05)
    list(2.84825e-09 0.110078038 0 1.87728297e-05)
    list(2.85025e-09 0.11007804 0 1.87029758e-05)
    list(2.85225e-09 0.110078042 0 1.86213399e-05)
    list(2.85425e-09 0.110078045 0 1.85209295e-05)
    list(2.85625e-09 0.110078047 0 1.84022229e-05)
    list(2.85825e-09 0.110078051 0 1.82726604e-05)
    list(2.86025e-09 0.110078054 0 1.81429899e-05)
    list(2.86225e-09 0.110078057 0 1.80228083e-05)
    list(2.86425e-09 0.110078061 0 1.7918069e-05)
    list(2.86625e-09 0.110078064 0 1.78309295e-05)
    list(2.86825e-09 0.110078068 0 1.77608238e-05)
    list(2.87025e-09 0.110078072 0 1.77057152e-05)
    list(2.87225e-09 0.110078076 0 1.76630426e-05)
    list(2.87425e-09 0.11007808 0 1.76302849e-05)
    list(2.87625e-09 0.110078084 0 1.76052286e-05)
    list(2.87825e-09 0.110078088 0 1.75860534e-05)
    list(2.88025e-09 0.110078092 0 1.75713215e-05)
    list(2.88225e-09 0.110078096 0 1.75599266e-05)
    list(2.88425e-09 0.1100781 0 1.75510321e-05)
    list(2.88625e-09 0.110078105 0 1.75440119e-05)
    list(2.88825e-09 0.110078109 0 1.75384007e-05)
    list(2.89025e-09 0.110078113 0 1.7533854e-05)
    list(2.89225e-09 0.110078118 0 1.75301168e-05)
    list(2.89425e-09 0.110078122 0 1.75270003e-05)
    list(2.89625e-09 0.110078127 0 1.75243643e-05)
    list(2.89825e-09 0.110078131 0 1.75221045e-05)
    list(2.9e-09 0.110078135 8.27180613e-14 1.7519812e-05)
    list(2.90075e-09 0.110165657 0.15 6.81412834e-06)
    list(2.90275e-09 0.110342773 0.55 -8.64284552e-06)
    list(2.90475e-09 0.110202618 0.95 1.62113832e-05)
    list(2.90535e-09 0.110118241 1 2.68450047e-05)
    list(2.90725e-09 0.109588603 1 1.23775435e-05)
    list(2.90925e-09 0.108994517 1 1.02810881e-05)
    list(2.91125e-09 0.108398824 1 9.7262564e-06)
    list(2.91325e-09 0.107805301 1 9.35665311e-06)
    list(2.91525e-09 0.107214299 1 9.01911388e-06)
    list(2.91725e-09 0.106625846 1 8.69113833e-06)
    list(2.91925e-09 0.106039939 1 8.36371641e-06)
    list(2.92125e-09 0.105456574 1 8.02514818e-06)
    list(2.92325e-09 0.104875746 1 7.65229025e-06)
    list(2.92525e-09 0.104297451 1 7.1983349e-06)
    list(2.92725e-09 0.103721684 1 6.60299591e-06)
    list(2.92925e-09 0.103148441 1 5.86728308e-06)
    list(2.93015e-09 0.102857883 0.97 2.26624085e-05)
    list(2.93175e-09 0.102021385 0.65 6.42257486e-06)
    list(2.93375e-09 0.10147254 0.25 4.9183665e-05)
    list(2.93505e-09 0.101314649 0 4.96842508e-05)
    list(2.93625e-09 0.101314637 0 2.55200053e-05)
    list(2.93825e-09 0.101314637 0 2.00751878e-05)
    list(2.94025e-09 0.101314637 0 1.93820025e-05)
    list(2.94225e-09 0.101314636 0 1.90884967e-05)
    list(2.94425e-09 0.101314637 0 1.893339e-05)
    list(2.94625e-09 0.101314637 0 1.88390639e-05)
    list(2.94825e-09 0.101314639 0 1.87672091e-05)
    list(2.95025e-09 0.10131464 0 1.86961637e-05)
    list(2.95225e-09 0.101314643 0 1.86126659e-05)
    list(2.95425e-09 0.101314645 0 1.851023e-05)
    list(2.95625e-09 0.101314648 0 1.83900014e-05)
    list(2.95825e-09 0.101314651 0 1.82599021e-05)
    list(2.96025e-09 0.101314654 0 1.81307317e-05)
    list(2.96225e-09 0.101314658 0 1.80117982e-05)
    list(2.96425e-09 0.101314661 0 1.79086668e-05)
    list(2.96625e-09 0.101314665 0 1.78231782e-05)
    list(2.96825e-09 0.101314669 0 1.77545742e-05)
    list(2.97025e-09 0.101314672 0 1.77007332e-05)
    list(2.97225e-09 0.101314676 0 1.76590792e-05)
    list(2.97425e-09 0.10131468 0 1.76271129e-05)
    list(2.97625e-09 0.101314684 0 1.7602657e-05)
    list(2.97825e-09 0.101314688 0 1.75839291e-05)
    list(2.98025e-09 0.101314693 0 1.7569526e-05)
    list(2.98225e-09 0.101314697 0 1.755837e-05)
    list(2.98425e-09 0.101314701 0 1.7549647e-05)
    list(2.98625e-09 0.101314705 0 1.75427486e-05)
    list(2.98825e-09 0.10131471 0 1.75372225e-05)
    list(2.99025e-09 0.101314714 0 1.7532734e-05)
    list(2.99225e-09 0.101314719 0 1.75290355e-05)
    list(2.99425e-09 0.101314723 0 1.75259436e-05)
    list(2.99625e-09 0.101314728 0 1.75233219e-05)
    list(2.99825e-09 0.101314732 0 1.7521069e-05)
    list(3e-09 0.101314736 0 1.75187738e-05)
    list(3.00075e-09 0.101403192 0.15 6.799323e-06)
    list(3.00275e-09 0.101584608 0.55 -8.54768719e-06)
    list(3.00475e-09 0.101497301 0.95 1.67379691e-05)
    list(3.00535e-09 0.101429314 1 2.7078475e-05)
    list(3.00725e-09 0.100940032 1 1.23458616e-05)
    list(3.00925e-09 0.100384232 1 1.02569543e-05)
    list(3.01125e-09 0.0998262423 1 9.70721986e-06)
    list(3.01325e-09 0.0992702864 1 9.33874122e-06)
    list(3.01525e-09 0.0987167723 1 9.00151355e-06)
    list(3.01725e-09 0.0981657344 1 8.67371918e-06)
    list(3.01925e-09 0.0976171713 1 8.34646656e-06)
    list(3.02125e-09 0.0970710783 1 8.0080943e-06)
    list(3.02325e-09 0.0965274503 1 7.63551243e-06)
    list(3.02525e-09 0.0959862825 1 7.18199323e-06)
    list(3.02725e-09 0.0954475696 1 6.58720981e-06)
    list(3.02925e-09 0.0949113069 1 5.85189951e-06)
    list(3.03015e-09 0.0946370605 0.97 2.26434243e-05)
    list(3.03175e-09 0.0938190808 0.65 6.22504471e-06)
    list(3.03375e-09 0.0932700796 0.25 4.93068119e-05)
    list(3.03505e-09 0.0931108132 0 4.95563391e-05)
    list(3.03625e-09 0.093110801 0 2.53767877e-05)
    list(3.03825e-09 0.0931108002 0 2.00668578e-05)
    list(3.04025e-09 0.0931108001 0 1.93855654e-05)
    list(3.04225e-09 0.0931107997 0 1.90946568e-05)
    list(3.04425e-09 0.0931107997 0 1.89398226e-05)
    list(3.04625e-09 0.0931108003 0 1.88445142e-05)
    list(3.04825e-09 0.0931108014 0 1.8770822e-05)
    list(3.05025e-09 0.0931108031 0 1.86972756e-05)
    list(3.05225e-09 0.0931108052 0 1.86108611e-05)
    list(3.05425e-09 0.0931108078 0 1.85055683e-05)
    list(3.05625e-09 0.0931108106 0 1.83831477e-05)
    list(3.05825e-09 0.0931108136 0 1.82519229e-05)
    list(3.06025e-09 0.0931108168 0 1.81226886e-05)
    list(3.06225e-09 0.0931108202 0 1.80044498e-05)
    list(3.06425e-09 0.0931108237 0 1.79023962e-05)
    list(3.06625e-09 0.0931108273 0 1.78180705e-05)
    list(3.06825e-09 0.093110831 0 1.77505355e-05)
    list(3.07025e-09 0.0931108348 0 1.76975897e-05)
    list(3.07225e-09 0.0931108387 0 1.76566406e-05)
    list(3.07425e-09 0.0931108427 0 1.76252052e-05)
    list(3.07625e-09 0.0931108467 0 1.76011355e-05)
    list(3.07825e-09 0.0931108509 0 1.75826804e-05)
    list(3.08025e-09 0.0931108551 0 1.75684645e-05)
    list(3.08225e-09 0.0931108593 0 1.75574333e-05)
    list(3.08425e-09 0.0931108637 0 1.75487904e-05)
    list(3.08625e-09 0.0931108681 0 1.75419409e-05)
    list(3.08825e-09 0.0931108725 0 1.75364426e-05)
    list(3.09025e-09 0.093110877 0 1.75319679e-05)
    list(3.09225e-09 0.0931108815 0 1.7528274e-05)
    list(3.09425e-09 0.0931108861 0 1.75251811e-05)
    list(3.09625e-09 0.0931108907 0 1.75225553e-05)
    list(3.09825e-09 0.0931108953 0 1.75202967e-05)
    list(3.1e-09 0.0931108994 0 1.75179902e-05)
    list(3.10075e-09 0.093200225 0.15 6.78497987e-06)
    list(3.10275e-09 0.0933861538 0.55 -8.3959122e-06)
    list(3.10475e-09 0.0933499324 0.95 1.72183917e-05)
    list(3.10535e-09 0.0932973359 1 2.72775108e-05)
    list(3.10725e-09 0.0928465749 1 1.23130166e-05)
    list(3.10925e-09 0.092327808 1 1.02337725e-05)
    list(3.11125e-09 0.0918063983 1 9.6889902e-06)
    list(3.11325e-09 0.0912869044 1 9.32155156e-06)
    list(3.11525e-09 0.0907697699 1 8.98460616e-06)
    list(3.11725e-09 0.0902550331 1 8.65697757e-06)
    list(3.11925e-09 0.0897426928 1 8.32988279e-06)
    list(3.12125e-09 0.0892327438 1 7.99169784e-06)
    list(3.12325e-09 0.0887251807 1 7.61938747e-06)
    list(3.12525e-09 0.0882199978 1 7.16630667e-06)
    list(3.12725e-09 0.0877171896 1 6.57208712e-06)
    list(3.12925e-09 0.0872167508 1 5.83718439e-06)
    list(3.13015e-09 0.0869583206 0.97 2.2624531e-05)
    list(3.13175e-09 0.0861588715 0.65 6.07564671e-06)
    list(3.13375e-09 0.0856105627 0.25 4.93672579e-05)
    list(3.13505e-09 0.0854500272 0 4.94252185e-05)
    list(3.13625e-09 0.0854500149 0 2.524844e-05)
    list(3.13825e-09 0.0854500139 0 2.00615599e-05)
    list(3.14025e-09 0.0854500135 0 1.9390697e-05)
    list(3.14225e-09 0.085450013 0 1.91018814e-05)
    list(3.14425e-09 0.0854500128 0 1.89470383e-05)
    list(3.14625e-09 0.0854500132 0 1.8850586e-05)
    list(3.14825e-09 0.0854500142 0 1.87749759e-05)
    list(3.15025e-09 0.0854500158 0 1.86989172e-05)
    list(3.15225e-09 0.0854500178 0 1.86096444e-05)
    list(3.15425e-09 0.0854500202 0 1.85016109e-05)
    list(3.15625e-09 0.0854500229 0 1.83771303e-05)
    list(3.15825e-09 0.0854500259 0 1.82448713e-05)
    list(3.16025e-09 0.0854500291 0 1.81155912e-05)
    list(3.16225e-09 0.0854500324 0 1.79979954e-05)
    list(3.16425e-09 0.0854500358 0 1.78969228e-05)
    list(3.16625e-09 0.0854500394 0 1.78136453e-05)
    list(3.16825e-09 0.0854500431 0 1.77470664e-05)
    list(3.17025e-09 0.0854500468 0 1.76949151e-05)
    list(3.17225e-09 0.0854500507 0 1.76545868e-05)
    list(3.17425e-09 0.0854500547 0 1.76236147e-05)
    list(3.17625e-09 0.0854500588 0 1.75998784e-05)
    list(3.17825e-09 0.0854500629 0 1.75816554e-05)
    list(3.18025e-09 0.0854500672 0 1.75675958e-05)
    list(3.18225e-09 0.0854500715 0 1.75566659e-05)
    list(3.18425e-09 0.0854500758 0 1.75480855e-05)
    list(3.18625e-09 0.0854500802 0 1.75412716e-05)
    list(3.18825e-09 0.0854500847 0 1.7535791e-05)
    list(3.19025e-09 0.0854500892 0 1.75313223e-05)
    list(3.19225e-09 0.0854500938 0 1.75276272e-05)
    list(3.19425e-09 0.0854500984 0 1.75245289e-05)
    list(3.19625e-09 0.085450103 0 1.75218956e-05)
    list(3.19825e-09 0.0854501077 0 1.75196287e-05)
    list(3.2e-09 0.0854501119 0 1.75173086e-05)
    list(3.20075e-09 0.0855402449 0.15 6.77094576e-06)
    list(3.20275e-09 0.0857308624 0.55 -8.28585676e-06)
    list(3.20475e-09 0.0857436791 0.95 1.75815685e-05)
    list(3.20535e-09 0.0857055034 1 2.74491062e-05)
    list(3.20725e-09 0.0852914263 1 1.22828359e-05)
    list(3.20925e-09 0.084808362 1 1.02143437e-05)
    list(3.21125e-09 0.0843223087 1 9.67388068e-06)
    list(3.21325e-09 0.0838380636 1 9.30702396e-06)
    list(3.21525e-09 0.0833560907 1 8.9700159e-06)
    list(3.21725e-09 0.0828764298 1 8.64226982e-06)
    list(3.21925e-09 0.0823990793 1 8.3150949e-06)
    list(3.22125e-09 0.0819240336 1 7.97689753e-06)
    list(3.22325e-09 0.0814512866 1 7.60469325e-06)
    list(3.22525e-09 0.0809808324 1 7.15191786e-06)
    list(3.22725e-09 0.0805126648 1 6.5581572e-06)
    list(3.22925e-09 0.0800467779 1 5.82357296e-06)
    list(3.23015e-09 0.0798036157 0.97 2.26055091e-05)
    list(3.23175e-09 0.0790225416 0.65 6.02881917e-06)
    list(3.23375e-09 0.0784756618 0.25 4.95360778e-05)
    list(3.23505e-09 0.0783139589 0 4.92831761e-05)
    list(3.23625e-09 0.0783139465 0 2.51266828e-05)
    list(3.23825e-09 0.0783139454 0 2.00531903e-05)
    list(3.24025e-09 0.0783139448 0 1.93923317e-05)
    list(3.24225e-09 0.0783139441 0 1.91059167e-05)
    list(3.24425e-09 0.0783139437 0 1.89514721e-05)
    list(3.24625e-09 0.078313944 0 1.88543042e-05)
    list(3.24825e-09 0.0783139448 0 1.87772019e-05)
    list(3.25025e-09 0.0783139463 0 1.86990541e-05)
    list(3.25225e-09 0.0783139482 0 1.8607351e-05)
    list(3.25425e-09 0.0783139505 0 1.8497003e-05)
    list(3.25625e-09 0.0783139532 0 1.83708514e-05)
    list(3.25825e-09 0.0783139561 0 1.82378652e-05)
    list(3.26025e-09 0.0783139592 0 1.81087437e-05)
    list(3.26225e-09 0.0783139624 0 1.79919037e-05)
    list(3.26425e-09 0.0783139658 0 1.78918618e-05)
    list(3.26625e-09 0.0783139694 0 1.78096469e-05)
    list(3.26825e-09 0.0783139731 0 1.77440232e-05)
    list(3.27025e-09 0.0783139768 0 1.76926624e-05)
    list(3.27225e-09 0.0783139807 0 1.76529527e-05)
    list(3.27425e-09 0.0783139847 0 1.76224454e-05)
    list(3.27625e-09 0.0783139888 0 1.75990474e-05)
    list(3.27825e-09 0.0783139929 0 1.7581064e-05)
    list(3.28025e-09 0.0783139972 0 1.75671696e-05)
    list(3.28225e-09 0.0783140015 0 1.75563503e-05)
    list(3.28425e-09 0.0783140059 0 1.75478414e-05)
    list(3.28625e-09 0.0783140103 0 1.75410716e-05)
    list(3.28825e-09 0.0783140148 0 1.7535616e-05)
    list(3.29025e-09 0.0783140194 0 1.75311595e-05)
    list(3.29225e-09 0.078314024 0 1.75274682e-05)
    list(3.29425e-09 0.0783140287 0 1.75243683e-05)
    list(3.29625e-09 0.0783140334 0 1.75217301e-05)
    list(3.29825e-09 0.0783140381 0 1.75194566e-05)
    list(3.3e-09 0.0783140423 0 1.7517124e-05)
    list(3.30075e-09 0.0784049219 0.15 6.75729735e-06)
    list(3.30275e-09 0.0786003988 0.55 -8.15385084e-06)
    list(3.30475e-09 0.0786600067 0.95 1.78958714e-05)
    list(3.30535e-09 0.0786353171 1 2.7593579e-05)
    list(3.30725e-09 0.078256083 1 1.22529079e-05)
    list(3.30925e-09 0.0778073042 1 1.01962185e-05)
    list(3.31125e-09 0.0773552733 1 9.65980863e-06)
    list(3.31325e-09 0.0769049486 1 9.29342344e-06)
    list(3.31525e-09 0.0764568031 1 8.95630334e-06)
    list(3.31725e-09 0.0760108765 1 8.62840655e-06)
    list(3.31925e-09 0.0755671668 1 8.30112507e-06)
    list(3.32125e-09 0.0751256678 1 7.96289416e-06)
    list(3.32325e-09 0.074686373 1 7.59078076e-06)
    list(3.32525e-09 0.074249276 1 7.13830333e-06)
    list(3.32725e-09 0.0738143702 1 6.54500117e-06)
    list(3.32925e-09 0.0733816492 1 5.81073416e-06)
    list(3.33015e-09 0.0731531538 0.97 2.25863866e-05)
    list(3.33175e-09 0.0723901035 0.65 6.32436546e-06)
    list(3.33375e-09 0.0718452544 0.25 5.03424424e-05)
    list(3.33505e-09 0.0716824826 0 4.9099373e-05)
    list(3.33625e-09 0.07168247 0 2.4990394e-05)
    list(3.33825e-09 0.0716824688 0 2.00228618e-05)
    list(3.34025e-09 0.0716824681 0 1.93743582e-05)
    list(3.34225e-09 0.0716824672 0 1.90930214e-05)
    list(3.34425e-09 0.0716824668 0 1.894142e-05)
    list(3.34625e-09 0.071682467 0 1.88457205e-05)
    list(3.34825e-09 0.0716824678 0 1.8769067e-05)
    list(3.35025e-09 0.0716824692 0 1.86905603e-05)
    list(3.35225e-09 0.0716824711 0 1.8597979e-05)
    list(3.35425e-09 0.0716824734 0 1.84867031e-05)
    list(3.35625e-09 0.0716824761 0 1.83600859e-05)
    list(3.35825e-09 0.071682479 0 1.82273743e-05)
    list(3.36025e-09 0.0716824821 0 1.80992106e-05)
    list(3.36225e-09 0.0716824854 0 1.79837521e-05)
    list(3.36425e-09 0.0716824888 0 1.78852328e-05)
    list(3.36625e-09 0.0716824924 0 1.78044759e-05)
    list(3.36825e-09 0.0716824961 0 1.77401336e-05)
    list(3.37025e-09 0.0716825 0 1.76898385e-05)
    list(3.37225e-09 0.0716825039 0 1.76509831e-05)
    list(3.37425e-09 0.071682508 0 1.7621144e-05)
    list(3.37625e-09 0.0716825121 0 1.75982597e-05)
    list(3.37825e-09 0.0716825164 0 1.75806668e-05)
    list(3.38025e-09 0.0716825207 0 1.75670668e-05)
    list(3.38225e-09 0.0716825251 0 1.7556468e-05)
    list(3.38425e-09 0.0716825296 0 1.75481234e-05)
    list(3.38625e-09 0.0716825342 0 1.75414752e-05)
    list(3.38825e-09 0.0716825388 0 1.75361088e-05)
    list(3.39025e-09 0.0716825435 0 1.75317171e-05)
    list(3.39225e-09 0.0716825482 0 1.7528072e-05)
    list(3.39425e-09 0.071682553 0 1.75250042e-05)
    list(3.39625e-09 0.0716825578 0 1.75223875e-05)
    list(3.39825e-09 0.0716825627 0 1.75201271e-05)
    list(3.4e-09 0.071682567 0 1.75177998e-05)
    list(3.40075e-09 0.0717741344 0.15 6.74423728e-06)
    list(3.40275e-09 0.0719746347 0.55 -7.99845439e-06)
    list(3.40475e-09 0.0720786707 0.95 1.81734324e-05)
    list(3.40535e-09 0.0720665695 1 2.77148083e-05)
    list(3.40725e-09 0.0717203352 1 1.22234287e-05)
    list(3.40925e-09 0.0713043405 1 1.01791603e-05)
    list(3.41125e-09 0.0708848928 1 9.64655606e-06)
    list(3.41325e-09 0.0704670516 1 9.28057682e-06)
    list(3.41525e-09 0.0700512911 1 8.94333302e-06)
    list(3.41725e-09 0.06963765 1 8.61528381e-06)
    list(3.41925e-09 0.0692261256 1 8.28789594e-06)
    list(3.42125e-09 0.0688167114 1 7.94963277e-06)
    list(3.42325e-09 0.0684094006 1 7.5776135e-06)
    list(3.42525e-09 0.0680041862 1 7.12544115e-06)
    list(3.42725e-09 0.0676010614 1 6.53260846e-06)
    list(3.42925e-09 0.0672000194 1 5.79866735e-06)
    list(3.43015e-09 0.0669855427 0.97 2.2567275e-05)
    list(3.43175e-09 0.0662400833 0.65 6.63865129e-06)
    list(3.43375e-09 0.0656977571 0.25 5.10895875e-05)
    list(3.43505e-09 0.0655340063 0 4.89199904e-05)
    list(3.43625e-09 0.0655339937 0 2.48632794e-05)
    list(3.43825e-09 0.0655339925 0 1.99945046e-05)
    list(3.44025e-09 0.0655339917 0 1.93573458e-05)
    list(3.44225e-09 0.0655339907 0 1.90807074e-05)
    list(3.44425e-09 0.0655339902 0 1.89317417e-05)
    list(3.44625e-09 0.0655339904 0 1.88373986e-05)
    list(3.44825e-09 0.0655339912 0 1.87611477e-05)
    list(3.45025e-09 0.0655339926 0 1.86822924e-05)
    list(3.45225e-09 0.0655339945 0 1.8588895e-05)
    list(3.45425e-09 0.0655339968 0 1.84767883e-05)
    list(3.45625e-09 0.0655339995 0 1.83497994e-05)
    list(3.45825e-09 0.0655340024 0 1.82174145e-05)
    list(3.46025e-09 0.0655340056 0 1.80902033e-05)
    list(3.46225e-09 0.0655340089 0 1.79760733e-05)
    list(3.46425e-09 0.0655340124 0 1.78789966e-05)
    list(3.46625e-09 0.0655340161 0 1.77996096e-05)
    list(3.46825e-09 0.0655340199 0 1.77364658e-05)
    list(3.47025e-09 0.0655340238 0 1.76871647e-05)
    list(3.47225e-09 0.0655340279 0 1.7649105e-05)
    list(3.47425e-09 0.0655340321 0 1.76198878e-05)
    list(3.47625e-09 0.0655340363 0 1.7597482e-05)
    list(3.47825e-09 0.0655340407 0 1.75802531e-05)
    list(3.48025e-09 0.0655340452 0 1.75669279e-05)
    list(3.48225e-09 0.0655340497 0 1.75565354e-05)
    list(3.48425e-09 0.0655340543 0 1.75483448e-05)
    list(3.48625e-09 0.065534059 0 1.75418109e-05)
    list(3.48825e-09 0.0655340638 0 1.75365288e-05)
    list(3.49025e-09 0.0655340686 0 1.75321984e-05)
    list(3.49225e-09 0.0655340735 0 1.75285974e-05)
    list(3.49425e-09 0.0655340784 0 1.75255605e-05)
    list(3.49625e-09 0.0655340834 0 1.75229646e-05)
    list(3.49825e-09 0.0655340885 0 1.75207174e-05)
    list(3.5e-09 0.0655340929 0 1.75183957e-05)
    list(3.50075e-09 0.0656262922 0.15 6.73156736e-06)
    list(3.50275e-09 0.0658319227 0.55 -7.83424744e-06)
    list(3.50475e-09 0.0659778912 0.95 1.84179696e-05)
    list(3.50535e-09 0.0659775137 1 2.78150019e-05)
    list(3.50725e-09 0.065662434 1 1.21945503e-05)
    list(3.50925e-09 0.0652776495 1 1.0163084e-05)
    list(3.51125e-09 0.0648892568 1 9.63404755e-06)
    list(3.51325e-09 0.0645023714 1 9.26842568e-06)
    list(3.51525e-09 0.0641174637 1 8.93105883e-06)
    list(3.51725e-09 0.0637345706 1 8.60286539e-06)
    list(3.51925e-09 0.0633536892 1 8.27537976e-06)
    list(3.52125e-09 0.0629748126 1 7.93709268e-06)
    list(3.52325e-09 0.0625979335 1 7.56517631e-06)
    list(3.52525e-09 0.062223045 1 7.11331971e-06)
    list(3.52725e-09 0.0618501399 1 6.52096937e-06)
    list(3.52925e-09 0.061479211 1 5.7873651e-06)
    list(3.53015e-09 0.0612780677 0.97 2.25483356e-05)
    list(3.53175e-09 0.0605495456 0.65 6.39010642e-06)
    list(3.53375e-09 0.0600101927 0.25 5.12601885e-05)
    list(3.53505e-09 0.0598455475 0 4.87791584e-05)
    list(3.53625e-09 0.0598455348 0 2.47700146e-05)
    list(3.53825e-09 0.0598455337 0 1.99883487e-05)
    list(3.54025e-09 0.0598455329 0 1.93588119e-05)
    list(3.54225e-09 0.059845532 0 1.90841307e-05)
    list(3.54425e-09 0.0598455315 0 1.89355412e-05)
    list(3.54625e-09 0.0598455317 0 1.88406646e-05)
    list(3.54825e-09 0.0598455326 0 1.87632326e-05)
    list(3.55025e-09 0.059845534 0 1.86827101e-05)
    list(3.55225e-09 0.059845536 0 1.85874092e-05)
    list(3.55425e-09 0.0598455385 0 1.84735708e-05)
    list(3.55625e-09 0.0598455413 0 1.83454365e-05)
    list(3.55825e-09 0.0598455443 0 1.82126784e-05)
    list(3.56025e-09 0.0598455476 0 1.8085767e-05)
    list(3.56225e-09 0.0598455511 0 1.79723567e-05)
    list(3.56425e-09 0.0598455548 0 1.78761692e-05)
    list(3.56625e-09 0.0598455586 0 1.77976592e-05)
    list(3.56825e-09 0.0598455626 0 1.77352847e-05)
    list(3.57025e-09 0.0598455667 0 1.768661e-05)
    list(3.57225e-09 0.059845571 0 1.76490345e-05)
    list(3.57425e-09 0.0598455753 0 1.76201774e-05)
    list(3.57625e-09 0.0598455798 0 1.75980306e-05)
    list(3.57825e-09 0.0598455844 0 1.75809824e-05)
    list(3.58025e-09 0.059845589 0 1.75677792e-05)
    list(3.58225e-09 0.0598455938 0 1.75574655e-05)
    list(3.58425e-09 0.0598455986 0 1.75493229e-05)
    list(3.58625e-09 0.0598456035 0 1.75428152e-05)
    list(3.58825e-09 0.0598456085 0 1.75375443e-05)
    list(3.59025e-09 0.0598456136 0 1.75332149e-05)
    list(3.59225e-09 0.0598456187 0 1.7529608e-05)
    list(3.59425e-09 0.0598456239 0 1.75265611e-05)
    list(3.59625e-09 0.0598456291 0 1.75239524e-05)
    list(3.59825e-09 0.0598456344 0 1.75216911e-05)
    list(3.6e-09 0.0598456391 8.27180613e-14 1.75193485e-05)
    list(3.60075e-09 0.0599384173 0.15 6.71944659e-06)
    list(3.60275e-09 0.0601492619 0.55 -7.66386555e-06)
    list(3.60475e-09 0.0603346462 0.95 1.86354012e-05)
    list(3.60535e-09 0.0603451669 1 2.78976717e-05)
    list(3.60725e-09 0.0600594094 1 1.21665495e-05)
    list(3.60925e-09 0.0597042075 1 1.0147946e-05)
    list(3.61125e-09 0.059345275 1 9.62224001e-06)
    list(3.61325e-09 0.0589877507 1 9.25694013e-06)
    list(3.61525e-09 0.0586320976 1 8.91946016e-06)
    list(3.61725e-09 0.0582783511 1 8.59113793e-06)
    list(3.61925e-09 0.0579265078 1 8.26356904e-06)
    list(3.62125e-09 0.0575765606 1 7.92527105e-06)
    list(3.62325e-09 0.0572285024 1 7.55346948e-06)
    list(3.62525e-09 0.0568823256 1 7.10194033e-06)
    list(3.62725e-09 0.0565380232 1 6.51008466e-06)
    list(3.62925e-09 0.056195588 1 5.77682821e-06)
    list(3.63015e-09 0.0560070673 0.97 2.25297415e-05)
    list(3.63175e-09 0.0552947764 0.65 5.83832143e-06)
    list(3.63375e-09 0.0547587088 0.25 5.10992221e-05)
    list(3.63505e-09 0.0545932478 0 4.86625927e-05)
    list(3.63625e-09 0.0545932352 0 2.4699006e-05)
    list(3.63825e-09 0.0545932342 0 1.99949725e-05)
    list(3.64025e-09 0.0545932336 0 1.93706928e-05)
    list(3.64225e-09 0.0545932328 0 1.9096354e-05)
    list(3.64425e-09 0.0545932324 0 1.89468472e-05)
    list(3.64625e-09 0.0545932328 0 1.88503788e-05)
    list(3.64825e-09 0.0545932338 0 1.87708981e-05)
    list(3.65025e-09 0.0545932354 0 1.86880058e-05)
    list(3.65225e-09 0.0545932376 0 1.85902414e-05)
    list(3.65425e-09 0.0545932402 0 1.84742192e-05)
    list(3.65625e-09 0.0545932432 0 1.83445481e-05)
    list(3.65825e-09 0.0545932465 0 1.82110454e-05)
    list(3.66025e-09 0.05459325 0 1.80840663e-05)
    list(3.66225e-09 0.0545932537 0 1.7971019e-05)
    list(3.66425e-09 0.0545932576 0 1.78753821e-05)
    list(3.66625e-09 0.0545932617 0 1.7797445e-05)
    list(3.66825e-09 0.0545932659 0 1.77355737e-05)
    list(3.67025e-09 0.0545932703 0 1.76872977e-05)
    list(3.67225e-09 0.0545932748 0 1.76500146e-05)
    list(3.67425e-09 0.0545932794 0 1.76213572e-05)
    list(3.67625e-09 0.0545932842 0 1.75993362e-05)
    list(3.67825e-09 0.054593289 0 1.75823583e-05)
    list(3.68025e-09 0.054593294 0 1.75691856e-05)
    list(3.68225e-09 0.0545932991 0 1.75588754e-05)
    list(3.68425e-09 0.0545933042 0 1.75507183e-05)
    list(3.68625e-09 0.0545933094 0 1.75441852e-05)
    list(3.68825e-09 0.0545933147 0 1.75388828e-05)
    list(3.69025e-09 0.0545933201 0 1.75345192e-05)
    list(3.69225e-09 0.0545933255 0 1.75308777e-05)
    list(3.69425e-09 0.054593331 0 1.75277969e-05)
    list(3.69625e-09 0.0545933366 0 1.75251562e-05)
    list(3.69825e-09 0.0545933422 0 1.7522865e-05)
    list(3.7e-09 0.0545933472 0 1.75204863e-05)
    list(3.70075e-09 0.0546866547 0.15 6.70784295e-06)
    list(3.70275e-09 0.0549027502 0.55 -7.49414143e-06)
    list(3.70475e-09 0.0551249668 0.95 1.88443398e-05)
    list(3.70535e-09 0.05514562 1 2.74954169e-05)
    list(3.70725e-09 0.0548873904 1 1.17194162e-05)
    list(3.70925e-09 0.0545601138 1 9.7574746e-06)
    list(3.71125e-09 0.0542290069 1 9.27432254e-06)
    list(3.71325e-09 0.0538992086 1 8.944386e-06)
    list(3.71525e-09 0.0535711732 1 8.63797716e-06)
    list(3.71725e-09 0.0532449346 1 8.33724361e-06)
    list(3.71925e-09 0.052920489 1 8.03421778e-06)
    list(3.72125e-09 0.0525978293 1 7.71778376e-06)
    list(3.72325e-09 0.0522769483 1 7.36552414e-06)
    list(3.72525e-09 0.0519578385 1 6.93157299e-06)
    list(3.72725e-09 0.0516404927 1 6.35552846e-06)
    list(3.72925e-09 0.0513249039 1 5.63621782e-06)
    list(3.73015e-09 0.0511482841 0.97 2.25175167e-05)
    list(3.73175e-09 0.0504515124 0.65 5.348391e-06)
    list(3.73375e-09 0.0499189087 0.25 5.09449755e-05)
    list(3.73505e-09 0.0497527047 0 4.85499478e-05)
    list(3.73625e-09 0.0497526922 0 2.46346621e-05)
    list(3.73825e-09 0.0497526914 0 2.00014398e-05)
    list(3.74025e-09 0.0497526909 0 1.93818726e-05)
    list(3.74225e-09 0.0497526903 0 1.91077952e-05)
    list(3.74425e-09 0.0497526902 0 1.89573973e-05)
    list(3.74625e-09 0.0497526907 0 1.88594163e-05)
    list(3.74825e-09 0.049752692 0 1.87780011e-05)
    list(3.75025e-09 0.0497526939 0 1.86928822e-05)
    list(3.75225e-09 0.0497526963 0 1.85928204e-05)
    list(3.75425e-09 0.0497526992 0 1.8474784e-05)
    list(3.75625e-09 0.0497527024 0 1.83437169e-05)
    list(3.75825e-09 0.049752706 0 1.82095569e-05)
    list(3.76025e-09 0.0497527098 0 1.808254e-05)
    list(3.76225e-09 0.0497527138 0 1.79698419e-05)
    list(3.76425e-09 0.049752718 0 1.787472e-05)
    list(3.76625e-09 0.0497527224 0 1.77973115e-05)
    list(3.76825e-09 0.0497527269 0 1.77359008e-05)
    list(3.77025e-09 0.0497527316 0 1.76879876e-05)
    list(3.77225e-09 0.0497527365 0 1.76509689e-05)
    list(3.77425e-09 0.0497527414 0 1.76224906e-05)
    list(3.77625e-09 0.0497527465 0 1.76005812e-05)
    list(3.77825e-09 0.0497527518 0 1.75836642e-05)
    list(3.78025e-09 0.0497527571 0 1.75705164e-05)
    list(3.78225e-09 0.0497527625 0 1.75602063e-05)
    list(3.78425e-09 0.049752768 0 1.75520333e-05)
    list(3.78625e-09 0.0497527736 0 1.75454745e-05)
    list(3.78825e-09 0.0497527792 0 1.75401412e-05)
    list(3.79025e-09 0.049752785 0 1.75357443e-05)
    list(3.79225e-09 0.0497527908 0 1.75320692e-05)
    list(3.79425e-09 0.0497527967 0 1.75289558e-05)
    list(3.79625e-09 0.0497528026 0 1.75262842e-05)
    list(3.79825e-09 0.0497528087 0 1.75239642e-05)
    list(3.8e-09 0.049752814 0 1.75215507e-05)
    list(3.80075e-09 0.0498466044 0.15 6.69670775e-06)
    list(3.80275e-09 0.0500679386 0.55 -7.33091355e-06)
    list(3.80475e-09 0.0503231243 0.95 1.93664597e-05)
    list(3.80535e-09 0.0503543691 1 2.83831231e-05)
    list(3.80725e-09 0.0501220343 1 1.23894524e-05)
    list(3.80925e-09 0.049821029 1 1.03617186e-05)
    list(3.81125e-09 0.0495160917 1 9.81548844e-06)
    list(3.81325e-09 0.0492123631 1 9.4275837e-06)
    list(3.81525e-09 0.0489102891 1 9.06932779e-06)
    list(3.81725e-09 0.0486099023 1 8.72247607e-06)
    list(3.81925e-09 0.0483111988 1 8.37848257e-06)
    list(3.82125e-09 0.0480141714 1 8.02569789e-06)
    list(3.82325e-09 0.0477188129 1 7.64125858e-06)
    list(3.82525e-09 0.0474251159 1 7.17894001e-06)
    list(3.82725e-09 0.0471330733 1 6.57789979e-06)
    list(3.82925e-09 0.0468426779 1 5.83629971e-06)
    list(3.83015e-09 0.0466772231 0.97 2.24902872e-05)
    list(3.83175e-09 0.0459952083 0.65 4.89662813e-06)
    list(3.83375e-09 0.0454661699 0.25 5.07831265e-05)
    list(3.83505e-09 0.0452992905 0 4.84427531e-05)
    list(3.83625e-09 0.0452992781 0 2.45770157e-05)
    list(3.83825e-09 0.0452992777 0 2.00082883e-05)
    list(3.84025e-09 0.0452992775 0 1.93928848e-05)
    list(3.84225e-09 0.0452992771 0 1.91189448e-05)
    list(3.84425e-09 0.0452992773 0 1.89676363e-05)
    list(3.84625e-09 0.0452992781 0 1.88681784e-05)
    list(3.84825e-09 0.0452992797 0 1.87849014e-05)
    list(3.85025e-09 0.0452992819 0 1.86976597e-05)
    list(3.85225e-09 0.0452992846 0 1.8595428e-05)
    list(3.85425e-09 0.0452992879 0 1.8475508e-05)
    list(3.85625e-09 0.0452992915 0 1.83431485e-05)
    list(3.85825e-09 0.0452992953 0 1.82083856e-05)
    list(3.86025e-09 0.0452992995 0 1.80813351e-05)
    list(3.86225e-09 0.0452993039 0 1.79689538e-05)
    list(3.86425e-09 0.0452993084 0 1.78742959e-05)
    list(3.86625e-09 0.0452993132 0 1.77973602e-05)
    list(3.86825e-09 0.0452993182 0 1.77363586e-05)
    list(3.87025e-09 0.0452993233 0 1.76887642e-05)
    list(3.87225e-09 0.0452993285 0 1.76519746e-05)
    list(3.87425e-09 0.0452993339 0 1.76236483e-05)
    list(3.87625e-09 0.0452993394 0 1.76018299e-05)
    list(3.87825e-09 0.045299345 0 1.75849586e-05)
    list(3.88025e-09 0.0452993508 0 1.75718244e-05)
    list(3.88225e-09 0.0452993566 0 1.75615062e-05)
    list(3.88425e-09 0.0452993626 0 1.75533114e-05)
    list(3.88625e-09 0.0452993686 0 1.75467226e-05)
    list(3.88825e-09 0.0452993747 0 1.7541355e-05)
    list(3.89025e-09 0.0452993809 0 1.75369224e-05)
    list(3.89225e-09 0.0452993872 0 1.75332118e-05)
    list(3.89425e-09 0.0452993935 0 1.75300643e-05)
    list(3.89625e-09 0.0452993999 0 1.75273606e-05)
    list(3.89825e-09 0.0452994064 0 1.75250109e-05)
    list(3.9e-09 0.0452994122 0 1.75225617e-05)
    list(3.90075e-09 0.0453936425 0.15 6.68606494e-06)
    list(3.90275e-09 0.0456201638 0.55 -7.1766342e-06)
    list(3.90475e-09 0.0459057298 0.95 1.9015798e-05)
    list(3.90535e-09 0.0459468263 1 2.92491627e-05)
    list(3.90725e-09 0.0457387631 1 1.30210892e-05)
    list(3.90925e-09 0.0454623748 1 1.09286936e-05)
    list(3.91125e-09 0.0451819602 1 1.03233021e-05)
    list(3.91325e-09 0.0449026551 1 9.8812121e-06)
    list(3.91525e-09 0.0446248975 1 9.47454101e-06)
    list(3.91725e-09 0.0443487187 1 9.08465103e-06)
    list(3.91925e-09 0.0440741147 1 8.70244783e-06)
    list(3.92125e-09 0.0438010785 1 8.31577983e-06)
    list(3.92325e-09 0.0435296029 1 7.90136582e-06)
    list(3.92525e-09 0.0432596807 1 7.41264774e-06)
    list(3.92725e-09 0.0429913048 1 6.78836812e-06)
    list(3.92925e-09 0.0427244683 1 6.02604985e-06)
    list(3.93015e-09 0.0425694576 0.97 2.24644973e-05)
    list(3.93175e-09 0.0419013245 0.65 5.30745693e-06)
    list(3.93375e-09 0.0413759375 0.25 5.1322293e-05)
    list(3.93505e-09 0.0412084458 0 4.82972623e-05)
    list(3.93625e-09 0.0412084336 0 2.44944317e-05)
    list(3.93825e-09 0.0412084336 0 1.99886059e-05)
    list(3.94025e-09 0.0412084338 0 1.93805043e-05)
    list(3.94225e-09 0.0412084338 0 1.9109738e-05)
    list(3.94425e-09 0.0412084344 0 1.89602293e-05)
    list(3.94625e-09 0.0412084356 0 1.88616891e-05)
    list(3.94825e-09 0.0412084376 0 1.87786616e-05)
    list(3.95025e-09 0.0412084402 0 1.86911612e-05)
    list(3.95225e-09 0.0412084434 0 1.85884042e-05)
    list(3.95425e-09 0.0412084471 0 1.84680374e-05)
    list(3.95625e-09 0.0412084511 0 1.83356137e-05)
    list(3.95825e-09 0.0412084555 0 1.82012727e-05)
    list(3.96025e-09 0.0412084601 0 1.80750317e-05)
    list(3.96225e-09 0.0412084649 0 1.79636603e-05)
    list(3.96425e-09 0.04120847 0 1.78700416e-05)
    list(3.96625e-09 0.0412084752 0 1.7794063e-05)
    list(3.96825e-09 0.0412084807 0 1.77338828e-05)
    list(3.97025e-09 0.0412084863 0 1.76869618e-05)
    list(3.97225e-09 0.041208492 0 1.76507071e-05)
    list(3.97425e-09 0.0412084979 0 1.76227971e-05)
    list(3.97625e-09 0.0412085039 0 1.7601298e-05)
    list(3.97825e-09 0.0412085101 0 1.75846693e-05)
    list(3.98025e-09 0.0412085164 0 1.7571718e-05)
    list(3.98225e-09 0.0412085227 0 1.75615368e-05)
    list(3.98425e-09 0.0412085292 0 1.75534441e-05)
    list(3.98625e-09 0.0412085358 0 1.75469307e-05)
    list(3.98825e-09 0.0412085424 0 1.75416183e-05)
    list(3.99025e-09 0.0412085492 0 1.75372256e-05)
    list(3.99225e-09 0.041208556 0 1.75335431e-05)
    list(3.99425e-09 0.0412085629 0 1.75304148e-05)
    list(3.99625e-09 0.0412085699 0 1.75277235e-05)
    list(3.99825e-09 0.041208577 0 1.75253808e-05)
    list(4e-09 0.0412085832 0 1.75229333e-05)
    list(4.00075e-09 0.0413032138 0.15 6.6760358e-06)
    list(4.00275e-09 0.0415348435 0.55 -7.03042874e-06)
    list(4.00475e-09 0.0418485072 0.95 1.86886659e-05)
    list(4.00535e-09 0.0418985734 1 2.83257459e-05)
    list(4.00725e-09 0.0417131558 1 1.2070032e-05)
    list(4.00925e-09 0.0414597614 1 1.00799852e-05)
    list(4.01125e-09 0.0412022535 1 9.56494806e-06)
    list(4.01325e-09 0.0409457567 1 9.20184858e-06)
    list(4.01525e-09 0.0406907019 1 8.86522741e-06)
    list(4.01725e-09 0.0404371192 1 8.53762958e-06)
    list(4.01925e-09 0.0401850048 1 8.21084322e-06)
    list(4.02125e-09 0.0399343518 1 7.87349571e-06)
    list(4.02325e-09 0.0396851533 1 7.50303178e-06)
    list(4.02525e-09 0.0394374024 1 7.05358008e-06)
    list(4.02725e-09 0.0391910922 1 6.46438163e-06)
    list(4.02925e-09 0.0389462161 1 5.73314064e-06)
    list(4.03015e-09 0.0388009547 0.97 2.2461903e-05)
    list(4.03175e-09 0.0381458829 0.65 5.81033496e-06)
    list(4.03375e-09 0.0376241286 0.25 5.19126297e-05)
    list(4.03505e-09 0.0374560811 0 4.81545186e-05)
    list(4.03625e-09 0.0374560693 0 2.4414934e-05)
    list(4.03825e-09 0.0374560697 0 1.99670091e-05)
    list(4.04025e-09 0.0374560704 0 1.93660275e-05)
    list(4.04225e-09 0.0374560709 0 1.90985688e-05)
    list(4.04425e-09 0.0374560719 0 1.89510543e-05)
    list(4.04625e-09 0.0374560737 0 1.88536492e-05)
    list(4.04825e-09 0.0374560761 0 1.87710995e-05)
    list(4.05025e-09 0.0374560793 0 1.86835761e-05)
    list(4.05225e-09 0.037456083 0 1.85805305e-05)
    list(4.05425e-09 0.0374560871 0 1.84599361e-05)
    list(4.05625e-09 0.0374560917 0 1.83276255e-05)
    list(4.05825e-09 0.0374560966 0 1.81938279e-05)
    list(4.06025e-09 0.0374561018 0 1.80684648e-05)
    list(4.06225e-09 0.0374561072 0 1.79581336e-05)
    list(4.06425e-09 0.0374561128 0 1.7865563e-05)
    list(4.06625e-09 0.0374561186 0 1.77905409e-05)
    list(4.06825e-09 0.0374561246 0 1.77311802e-05)
    list(4.07025e-09 0.0374561307 0 1.76849323e-05)
    list(4.07225e-09 0.0374561371 0 1.76492157e-05)
    list(4.07425e-09 0.0374561436 0 1.76217279e-05)
    list(4.07625e-09 0.0374561502 0 1.76005563e-05)
    list(4.07825e-09 0.0374561569 0 1.75841797e-05)
    list(4.08025e-09 0.0374561638 0 1.75714215e-05)
    list(4.08225e-09 0.0374561708 0 1.75613878e-05)
    list(4.08425e-09 0.0374561779 0 1.75534072e-05)
    list(4.08625e-09 0.037456185 0 1.7546979e-05)
    list(4.08825e-09 0.0374561923 0 1.75417307e-05)
    list(4.09025e-09 0.0374561997 0 1.75373859e-05)
    list(4.09225e-09 0.0374562071 0 1.7533739e-05)
    list(4.09425e-09 0.0374562147 0 1.75306365e-05)
    list(4.09625e-09 0.0374562223 0 1.75279635e-05)
    list(4.09825e-09 0.03745623 0 1.75256332e-05)
    list(4.1e-09 0.0374562368 0 1.75231932e-05)
    list(4.10075e-09 0.037551231 0.15 6.66653165e-06)
    list(4.10275e-09 0.0377878476 0.55 -6.89562383e-06)
    list(4.10475e-09 0.0381273757 0.95 1.88722218e-05)
    list(4.10535e-09 0.0381856987 1 2.74619205e-05)
    list(4.10725e-09 0.0380213294 1 1.11744477e-05)
    list(4.10925e-09 0.0377893432 1 9.28032853e-06)
    list(4.11125e-09 0.0375531598 1 8.85045716e-06)
    list(4.11325e-09 0.0373178919 1 8.56190765e-06)
    list(4.11525e-09 0.0370839635 1 8.29141334e-06)
    list(4.11725e-09 0.0368514039 1 8.02262123e-06)
    list(4.11925e-09 0.0366202094 1 7.74815068e-06)
    list(4.12125e-09 0.0363903735 1 7.45736474e-06)
    list(4.12325e-09 0.0361618895 1 7.12839474e-06)
    list(4.12525e-09 0.0359347508 1 6.71601991e-06)
    list(4.12725e-09 0.0357089508 1 6.15995164e-06)
    list(4.12925e-09 0.0354844831 1 5.45805766e-06)
    list(4.13015e-09 0.0353482847 0.97 2.24594387e-05)
    list(4.13175e-09 0.0347054621 0.65 6.28185016e-06)
    list(4.13375e-09 0.0341872721 0.25 5.24524783e-05)
    list(4.13505e-09 0.0340187208 0 4.802096e-05)
    list(4.13625e-09 0.0340187093 0 2.43425236e-05)
    list(4.13825e-09 0.0340187104 0 1.99462756e-05)
    list(4.14025e-09 0.0340187116 0 1.93529317e-05)
    list(4.14225e-09 0.0340187126 0 1.90884872e-05)
    list(4.14425e-09 0.0340187142 0 1.89427672e-05)
    list(4.14625e-09 0.0340187165 0 1.8846368e-05)
    list(4.14825e-09 0.0340187195 0 1.87642201e-05)
    list(4.15025e-09 0.0340187232 0 1.86766415e-05)
    list(4.15225e-09 0.0340187275 0 1.8573307e-05)
    list(4.15425e-09 0.0340187323 0 1.84524957e-05)
    list(4.15625e-09 0.0340187375 0 1.83202951e-05)
    list(4.15825e-09 0.034018743 0 1.81870088e-05)
    list(4.16025e-09 0.0340187487 0 1.80624637e-05)
    list(4.16225e-09 0.0340187547 0 1.79530958e-05)
    list(4.16425e-09 0.034018761 0 1.78614915e-05)
    list(4.16625e-09 0.0340187674 0 1.77873488e-05)
    list(4.16825e-09 0.034018774 0 1.77287394e-05)
    list(4.17025e-09 0.0340187809 0 1.76831075e-05)
    list(4.17225e-09 0.0340187878 0 1.76478822e-05)
    list(4.17425e-09 0.034018795 0 1.76207793e-05)
    list(4.17625e-09 0.0340188022 0 1.75999056e-05)
    list(4.17825e-09 0.0340188096 0 1.75837579e-05)
    list(4.18025e-09 0.0340188172 0 1.75711746e-05)
    list(4.18225e-09 0.0340188248 0 1.7561274e-05)
    list(4.18425e-09 0.0340188326 0 1.75533944e-05)
    list(4.18625e-09 0.0340188404 0 1.75470423e-05)
    list(4.18825e-09 0.0340188484 0 1.75418512e-05)
    list(4.19025e-09 0.0340188565 0 1.7537549e-05)
    list(4.19225e-09 0.0340188646 0 1.75339333e-05)
    list(4.19425e-09 0.0340188728 0 1.75308532e-05)
    list(4.19625e-09 0.0340188812 0 1.75281957e-05)
    list(4.19825e-09 0.0340188896 0 1.75258757e-05)
    list(4.2e-09 0.034018897 0 1.75234413e-05)
    list(4.20075e-09 0.0341142214 0.15 6.65754488e-06)
    list(4.20275e-09 0.034355673 0.55 -6.77276164e-06)
    list(4.20475e-09 0.0347189547 0.95 1.92351503e-05)
    list(4.20535e-09 0.034783917 1 2.74674318e-05)
    list(4.20725e-09 0.0346400296 1 1.15711944e-05)
    list(4.20925e-09 0.0344279261 1 9.63175616e-06)
    list(4.21125e-09 0.0342115343 1 9.1648591e-06)
    list(4.21325e-09 0.0339959654 1 8.84256797e-06)
    list(4.21525e-09 0.0337816377 1 8.54190437e-06)
    list(4.21725e-09 0.0335685802 1 8.24627199e-06)
    list(4.21925e-09 0.0333567891 1 7.94795764e-06)
    list(4.22125e-09 0.0331462583 1 7.63602331e-06)
    list(4.22325e-09 0.0329369813 1 7.28835986e-06)
    list(4.22525e-09 0.0327289518 1 6.85956794e-06)
    list(4.22725e-09 0.0325221635 1 6.28909386e-06)
    list(4.22925e-09 0.0323166104 1 5.57432136e-06)
    list(4.23015e-09 0.0321888044 0.97 2.24396274e-05)
    list(4.23175e-09 0.0315574283 0.65 6.70752909e-06)
    list(4.23375e-09 0.0310426999 0.25 5.29319928e-05)
    list(4.23505e-09 0.0308736917 0 4.7897115e-05)
    list(4.23625e-09 0.0308736806 0 2.42772037e-05)
    list(4.23825e-09 0.0308736823 0 1.99289771e-05)
    list(4.24025e-09 0.0308736841 0 1.93414243e-05)
    list(4.24225e-09 0.0308736857 0 1.90796629e-05)
    list(4.24425e-09 0.0308736879 0 1.89355331e-05)
    list(4.24625e-09 0.0308736909 0 1.88400047e-05)
    list(4.24825e-09 0.0308736946 0 1.87581774e-05)
    list(4.25025e-09 0.0308736989 0 1.86705071e-05)
    list(4.25225e-09 0.0308737038 0 1.85668786e-05)
    list(4.25425e-09 0.0308737093 0 1.84458534e-05)
    list(4.25625e-09 0.0308737151 0 1.83137481e-05)
    list(4.25825e-09 0.0308737212 0 1.81809274e-05)
    list(4.26025e-09 0.0308737277 0 1.80571264e-05)
    list(4.26225e-09 0.0308737344 0 1.79486322e-05)
    list(4.26425e-09 0.0308737413 0 1.78579015e-05)
    list(4.26625e-09 0.0308737484 0 1.77845514e-05)
    list(4.26825e-09 0.0308737558 0 1.77266174e-05)
    list(4.27025e-09 0.0308737633 0 1.76815376e-05)
    list(4.27225e-09 0.030873771 0 1.76467513e-05)
    list(4.27425e-09 0.0308737788 0 1.7619991e-05)
    list(4.27625e-09 0.0308737868 0 1.75993815e-05)
    list(4.27825e-09 0.0308737949 0 1.75834357e-05)
    list(4.28025e-09 0.0308738032 0 1.75710058e-05)
    list(4.28225e-09 0.0308738116 0 1.75612211e-05)
    list(4.28425e-09 0.0308738201 0 1.75534287e-05)
    list(4.28625e-09 0.0308738287 0 1.75471417e-05)
    list(4.28825e-09 0.0308738374 0 1.75419989e-05)
    list(4.29025e-09 0.0308738462 0 1.75377319e-05)
    list(4.29225e-09 0.0308738551 0 1.75341414e-05)
    list(4.29425e-09 0.030873864 0 1.75310789e-05)
    list(4.29625e-09 0.0308738731 0 1.7528433e-05)
    list(4.29825e-09 0.0308738823 0 1.752612e-05)
    list(4.3e-09 0.0308738904 0 1.75236882e-05)
    list(4.30075e-09 0.0309695143 0.15 6.64907613e-06)
    list(4.30275e-09 0.0312156252 0.55 -6.661637e-06)
    list(4.30475e-09 0.0316006949 0.95 1.95594e-05)
    list(4.30535e-09 0.0316717361 1 2.74735973e-05)
    list(4.30725e-09 0.0315467796 1 1.19400568e-05)
    list(4.30925e-09 0.0313530879 1 9.95839272e-06)
    list(4.31125e-09 0.0311550218 1 9.45701687e-06)
    list(4.31325e-09 0.0309576897 1 9.10336514e-06)
    list(4.31525e-09 0.0307615052 1 8.7746695e-06)
    list(4.31725e-09 0.0305664965 1 8.4540998e-06)
    list(4.31925e-09 0.0303726602 1 8.13363296e-06)
    list(4.32125e-09 0.0301799905 1 7.80205167e-06)
    list(4.32325e-09 0.0299884811 1 7.43702467e-06)
    list(4.32525e-09 0.029798126 1 6.9929891e-06)
    list(4.32725e-09 0.0296089194 1 6.40914462e-06)
    list(4.32925e-09 0.0294208553 1 5.68241753e-06)
    list(4.33015e-09 0.0293008109 0.97 2.24211281e-05)
    list(4.33175e-09 0.028680047 0.65 7.10304389e-06)
    list(4.33375e-09 0.0281686478 0.25 5.33693346e-05)
    list(4.33505e-09 0.0279992259 0 4.77819105e-05)
    list(4.33625e-09 0.0279992152 0 2.42177687e-05)
    list(4.33825e-09 0.0279992176 0 1.99132737e-05)
    list(4.34025e-09 0.0279992201 0 1.93309793e-05)
    list(4.34225e-09 0.0279992224 0 1.90716538e-05)
    list(4.34425e-09 0.0279992253 0 1.89289608e-05)
    list(4.34625e-09 0.0279992289 0 1.88342101e-05)
    list(4.34825e-09 0.0279992333 0 1.87526557e-05)
    list(4.35025e-09 0.0279992383 0 1.8664883e-05)
    list(4.35225e-09 0.027999244 0 1.85609745e-05)
    list(4.35425e-09 0.0279992501 0 1.84397535e-05)
    list(4.35625e-09 0.0279992566 0 1.83077442e-05)
    list(4.35825e-09 0.0279992635 0 1.81753611e-05)
    list(4.36025e-09 0.0279992707 0 1.80522511e-05)
    list(4.36225e-09 0.0279992781 0 1.79445628e-05)
    list(4.36425e-09 0.0279992858 0 1.7854635e-05)
    list(4.36625e-09 0.0279992936 0 1.77820111e-05)
    list(4.36825e-09 0.0279993017 0 1.77246948e-05)
    list(4.37025e-09 0.02799931 0 1.76801191e-05)
    list(4.37225e-09 0.0279993184 0 1.76457331e-05)
    list(4.37425e-09 0.027999327 0 1.76192849e-05)
    list(4.37625e-09 0.0279993358 0 1.75989157e-05)
    list(4.37825e-09 0.0279993447 0 1.75831533e-05)
    list(4.38025e-09 0.0279993537 0 1.75708626e-05)
    list(4.38225e-09 0.0279993629 0 1.7561183e-05)
    list(4.38425e-09 0.0279993722 0 1.75534693e-05)
    list(4.38625e-09 0.0279993815 0 1.75472411e-05)
    list(4.38825e-09 0.027999391 0 1.75421416e-05)
    list(4.39025e-09 0.0279994006 0 1.75379061e-05)
    list(4.39225e-09 0.0279994103 0 1.75343381e-05)
    list(4.39425e-09 0.0279994201 0 1.7531291e-05)
    list(4.39625e-09 0.02799943 0 1.75286552e-05)
    list(4.39825e-09 0.02799944 0 1.75263482e-05)
    list(4.4e-09 0.0279994488 0 1.7523918e-05)
    list(4.40075e-09 0.0280953443 0.15 6.64111963e-06)
    list(4.40275e-09 0.0283459191 0.55 -6.56180388e-06)
    list(4.40475e-09 0.0287509413 0.95 1.98481597e-05)
    list(4.40535e-09 0.0288275465 1 2.74773245e-05)
    list(4.40725e-09 0.0287200491 1 1.22776512e-05)
    list(4.40925e-09 0.0285433707 1 1.02572017e-05)
    list(4.41125e-09 0.0283622342 1 9.72422933e-06)
    list(4.41325e-09 0.0281817471 1 9.34188326e-06)
    list(4.41525e-09 0.0280023185 1 8.98754427e-06)
    list(4.41725e-09 0.0278239764 1 8.64416332e-06)
    list(4.41925e-09 0.0276467175 1 8.30343348e-06)
    list(4.42125e-09 0.0274705363 1 7.95388263e-06)
    list(4.42325e-09 0.0272954268 1 7.57297803e-06)
    list(4.42525e-09 0.0271213835 1 7.11501021e-06)
    list(4.42725e-09 0.0269484006 1 6.51895263e-06)
    list(4.42925e-09 0.0267764727 1 5.78130328e-06)
    list(4.43015e-09 0.0266635909 0.97 2.24039788e-05)
    list(4.43175e-09 0.0260527391 0.65 7.47029042e-06)
    list(4.43375e-09 0.0255445268 0.25 5.3767794e-05)
    list(4.43505e-09 0.0253747306 0 4.76751275e-05)
    list(4.43625e-09 0.0253747203 0 2.41637621e-05)
    list(4.43825e-09 0.0253747235 0 1.98990271e-05)
    list(4.44025e-09 0.0253747267 0 1.93215024e-05)
    list(4.44225e-09 0.0253747298 0 1.90643861e-05)
    list(4.44425e-09 0.0253747334 0 1.8922991e-05)
    list(4.44625e-09 0.0253747377 0 1.88289349e-05)
    list(4.44825e-09 0.0253747428 0 1.87476132e-05)
    list(4.45025e-09 0.0253747486 0 1.86597322e-05)
    list(4.45225e-09 0.025374755 0 1.85555596e-05)
    list(4.45425e-09 0.0253747619 0 1.84341607e-05)
    list(4.45625e-09 0.0253747692 0 1.8302247e-05)
    list(4.45825e-09 0.0253747768 0 1.81702739e-05)
    list(4.46025e-09 0.0253747848 0 1.80478038e-05)
    list(4.46225e-09 0.025374793 0 1.79408576e-05)
    list(4.46425e-09 0.0253748014 0 1.7851666e-05)
    list(4.46625e-09 0.0253748101 0 1.77797067e-05)
    list(4.46825e-09 0.0253748189 0 1.77229544e-05)
    list(4.47025e-09 0.025374828 0 1.76788384e-05)
    list(4.47225e-09 0.0253748372 0 1.7644817e-05)
    list(4.47425e-09 0.0253748467 0 1.76186527e-05)
    list(4.47625e-09 0.0253748562 0 1.75985019e-05)
    list(4.47825e-09 0.0253748659 0 1.75829061e-05)
    list(4.48025e-09 0.0253748758 0 1.75707416e-05)
    list(4.48225e-09 0.0253748858 0 1.75611571e-05)
    list(4.48425e-09 0.0253748959 0 1.75535146e-05)
    list(4.48625e-09 0.0253749061 0 1.75473394e-05)
    list(4.48825e-09 0.0253749164 0 1.75422788e-05)
    list(4.49025e-09 0.0253749268 0 1.75380716e-05)
    list(4.49225e-09 0.0253749374 0 1.75345235e-05)
    list(4.49425e-09 0.025374948 0 1.75314901e-05)
    list(4.49625e-09 0.0253749587 0 1.75288631e-05)
    list(4.49825e-09 0.0253749696 0 1.75265611e-05)
    list(4.5e-09 0.0253749791 1.65436123e-13 1.75241321e-05)
    list(4.50075e-09 0.0254711208 0.15 6.63367363e-06)
    list(4.50275e-09 0.0257259502 0.55 -6.47239988e-06)
    list(4.50475e-09 0.0261492183 0.95 2.0104701e-05)
    list(4.50535e-09 0.0262309109 1 2.74792116e-05)
    list(4.50725e-09 0.0261394857 1 1.25862901e-05)
    list(4.50925e-09 0.0259784888 1 1.05302126e-05)
    list(4.51125e-09 0.0258129591 1 9.9684324e-06)
    list(4.51325e-09 0.0256479987 1 9.55985844e-06)
    list(4.51525e-09 0.0254840128 1 9.18207888e-06)
    list(4.51725e-09 0.025321029 1 8.81784679e-06)
    list(4.51925e-09 0.0251590444 1 8.45859597e-06)
    list(4.52125e-09 0.0249980536 1 8.09262191e-06)
    list(4.52325e-09 0.0248380511 1 7.69720909e-06)
    list(4.52525e-09 0.0246790316 1 7.22651653e-06)
    list(4.52725e-09 0.0245209898 1 6.61931049e-06)
    list(4.52925e-09 0.0243639204 1 5.87168908e-06)
    list(4.53015e-09 0.0242576352 0.97 2.23881232e-05)
    list(4.53175e-09 0.0236559313 0.65 7.30658966e-06)
    list(4.53375e-09 0.0231507531 0.25 5.36899875e-05)
    list(4.53505e-09 0.0229806183 0 4.76036973e-05)
    list(4.53625e-09 0.0229806085 0 2.41339098e-05)
    list(4.53825e-09 0.0229806124 0 1.99027314e-05)
    list(4.54025e-09 0.0229806164 0 1.9327281e-05)
    list(4.54225e-09 0.0229806203 0 1.90702174e-05)
    list(4.54425e-09 0.0229806246 0 1.89283062e-05)
    list(4.54625e-09 0.0229806298 0 1.88334102e-05)
    list(4.54825e-09 0.0229806357 0 1.87510236e-05)
    list(4.55025e-09 0.0229806422 0 1.86619397e-05)
    list(4.55225e-09 0.0229806494 0 1.85565763e-05)
    list(4.55425e-09 0.0229806571 0 1.84342025e-05)
    list(4.55625e-09 0.0229806651 0 1.83016816e-05)
    list(4.55825e-09 0.0229806736 0 1.81694872e-05)
    list(4.56025e-09 0.0229806823 0 1.80470882e-05)
    list(4.56225e-09 0.0229806913 0 1.79403765e-05)
    list(4.56425e-09 0.0229807006 0 1.78514749e-05)
    list(4.56625e-09 0.0229807101 0 1.77797926e-05)
    list(4.56825e-09 0.0229807198 0 1.77232716e-05)
    list(4.57025e-09 0.0229807297 0 1.76793317e-05)
    list(4.57225e-09 0.0229807397 0 1.76454344e-05)
    list(4.57425e-09 0.02298075 0 1.76193507e-05)
    list(4.57625e-09 0.0229807604 0 1.75992467e-05)
    list(4.57825e-09 0.022980771 0 1.75836729e-05)
    list(4.58025e-09 0.0229807817 0 1.75715128e-05)
    list(4.58225e-09 0.0229807925 0 1.7561921e-05)
    list(4.58425e-09 0.0229808035 0 1.75542638e-05)
    list(4.58625e-09 0.0229808145 0 1.75480694e-05)
    list(4.58825e-09 0.0229808257 0 1.75429875e-05)
    list(4.59025e-09 0.022980837 0 1.75387581e-05)
    list(4.59225e-09 0.0229808484 0 1.75351881e-05)
    list(4.59425e-09 0.02298086 0 1.75321336e-05)
    list(4.59625e-09 0.0229808716 0 1.75294866e-05)
    list(4.59825e-09 0.0229808833 0 1.75271658e-05)
    list(4.6e-09 0.0229808936 0 1.75247144e-05)
    list(4.60075e-09 0.0230772582 0.15 6.62673255e-06)
    list(4.60275e-09 0.0233361243 0.55 -6.39231595e-06)
    list(4.60475e-09 0.0237760536 0.95 2.02882783e-05)
    list(4.60535e-09 0.0238623972 1 2.74822784e-05)
    list(4.60725e-09 0.0237857417 1 1.28330734e-05)
    list(4.60925e-09 0.0236391764 1 1.07476212e-05)
    list(4.61125e-09 0.0234880073 1 1.01628206e-05)
    list(4.61325e-09 0.023337332 1 9.73328564e-06)
    list(4.61525e-09 0.0231875524 1 9.33676423e-06)
    list(4.61725e-09 0.0230386955 1 8.95586243e-06)
    list(4.61925e-09 0.0228907589 1 8.58180893e-06)
    list(4.62125e-09 0.0227437374 1 8.20271582e-06)
    list(4.62325e-09 0.0225976259 1 7.79572729e-06)
    list(4.62525e-09 0.0224524194 1 7.31490707e-06)
    list(4.62725e-09 0.0223081129 1 6.69885212e-06)
    list(4.62925e-09 0.0221647016 1 5.94330654e-06)
    list(4.63015e-09 0.022064481 0.97 2.23740059e-05)
    list(4.63175e-09 0.0214712818 0.65 6.8026592e-06)
    list(4.63375e-09 0.0209689804 0.25 5.33041078e-05)
    list(4.63505e-09 0.0207985393 0 4.75570236e-05)
    list(4.63625e-09 0.02079853 0 2.41205944e-05)
    list(4.63825e-09 0.0207985348 0 1.99189881e-05)
    list(4.64025e-09 0.0207985396 0 1.93427588e-05)
    list(4.64225e-09 0.0207985443 0 1.90843381e-05)
    list(4.64425e-09 0.0207985495 0 1.89407544e-05)
    list(4.64625e-09 0.0207985554 0 1.88440516e-05)
    list(4.64825e-09 0.0207985621 0 1.87597935e-05)
    list(4.65025e-09 0.0207985694 0 1.86688359e-05)
    list(4.65225e-09 0.0207985774 0 1.85617204e-05)
    list(4.65425e-09 0.0207985859 0 1.8437888e-05)
    list(4.65625e-09 0.0207985948 0 1.83043258e-05)
    list(4.65825e-09 0.0207986041 0 1.81715097e-05)
    list(4.66025e-09 0.0207986137 0 1.80488121e-05)
    list(4.66225e-09 0.0207986235 0 1.79419993e-05)
    list(4.66425e-09 0.0207986336 0 1.78530894e-05)
    list(4.66625e-09 0.0207986439 0 1.77814245e-05)
    list(4.66825e-09 0.0207986545 0 1.77249119e-05)
    list(4.67025e-09 0.0207986652 0 1.76809588e-05)
    list(4.67225e-09 0.0207986762 0 1.76470258e-05)
    list(4.67425e-09 0.0207986873 0 1.76208885e-05)
    list(4.67625e-09 0.0207986986 0 1.76007188e-05)
    list(4.67825e-09 0.02079871 0 1.75850727e-05)
    list(4.68025e-09 0.0207987216 0 1.75728383e-05)
    list(4.68225e-09 0.0207987333 0 1.75631734e-05)
    list(4.68425e-09 0.0207987451 0 1.75554465e-05)
    list(4.68625e-09 0.0207987571 0 1.75491871e-05)
    list(4.68825e-09 0.0207987691 0 1.75440456e-05)
    list(4.69025e-09 0.0207987813 0 1.75397623e-05)
    list(4.69225e-09 0.0207987936 0 1.75361441e-05)
    list(4.69425e-09 0.0207988061 0 1.75330467e-05)
    list(4.69625e-09 0.0207988186 0 1.75303618e-05)
    list(4.69825e-09 0.0207988312 0 1.75280078e-05)
    list(4.7e-09 0.0207988423 0 1.75255195e-05)
    list(4.70075e-09 0.0208954087 0.15 6.62028308e-06)
    list(4.70275e-09 0.0211580874 0.55 -6.32073488e-06)
    list(4.70475e-09 0.021613182 0.95 2.01596723e-05)
    list(4.70535e-09 0.0217037918 1 2.75009825e-05)
    list(4.70725e-09 0.0216406569 1 1.26250865e-05)
    list(4.70925e-09 0.021507373 1 1.05532407e-05)
    list(4.71125e-09 0.0213693986 1 9.98835354e-06)
    list(4.71325e-09 0.0212318455 1 9.57654447e-06)
    list(4.71525e-09 0.0210951137 1 9.19576365e-06)
    list(4.71725e-09 0.0209592304 1 8.8288818e-06)
    list(4.71925e-09 0.0208241932 1 8.46732867e-06)
    list(4.72125e-09 0.0206899975 1 8.09939929e-06)
    list(4.72325e-09 0.0205566385 1 7.70242391e-06)
    list(4.72525e-09 0.0204241115 1 7.23066089e-06)
    list(4.72725e-09 0.0202924118 1 6.62280245e-06)
    list(4.72925e-09 0.0201615349 1 5.874487e-06)
    list(4.73015e-09 0.0200668843 0.97 2.23672644e-05)
    list(4.73175e-09 0.0194814781 0.65 6.34967347e-06)
    list(4.73375e-09 0.018981876 0.25 5.29552072e-05)
    list(4.73505e-09 0.018811158 0 4.75132862e-05)
    list(4.73625e-09 0.0188111492 0 2.41084231e-05)
    list(4.73825e-09 0.0188111549 0 1.99328181e-05)
    list(4.74025e-09 0.0188111605 0 1.93568448e-05)
    list(4.74225e-09 0.018811166 0 1.90971964e-05)
    list(4.74425e-09 0.018811172 0 1.89520818e-05)
    list(4.74625e-09 0.0188111787 0 1.88537238e-05)
    list(4.74825e-09 0.0188111862 0 1.87677495e-05)
    list(4.75025e-09 0.0188111944 0 1.86750737e-05)
    list(4.75225e-09 0.0188112032 0 1.85663545e-05)
    list(4.75425e-09 0.0188112125 0 1.84411925e-05)
    list(4.75625e-09 0.0188112223 0 1.83066871e-05)
    list(4.75825e-09 0.0188112324 0 1.81733135e-05)
    list(4.76025e-09 0.0188112428 0 1.80503536e-05)
    list(4.76225e-09 0.0188112535 0 1.79434574e-05)
    list(4.76425e-09 0.0188112644 0 1.78545469e-05)
    list(4.76625e-09 0.0188112756 0 1.77829031e-05)
    list(4.76825e-09 0.018811287 0 1.77264021e-05)
    list(4.77025e-09 0.0188112986 0 1.76824399e-05)
    list(4.77225e-09 0.0188113104 0 1.76484766e-05)
    list(4.77425e-09 0.0188113224 0 1.76222921e-05)
    list(4.77625e-09 0.0188113345 0 1.76020636e-05)
    list(4.77825e-09 0.0188113468 0 1.75863526e-05)
    list(4.78025e-09 0.0188113593 0 1.75740511e-05)
    list(4.78225e-09 0.0188113719 0 1.756432e-05)
    list(4.78425e-09 0.0188113846 0 1.75565299e-05)
    list(4.78625e-09 0.0188113975 0 1.75502115e-05)
    list(4.78825e-09 0.0188114104 0 1.75450159e-05)
    list(4.79025e-09 0.0188114235 0 1.75406836e-05)
    list(4.79225e-09 0.0188114367 0 1.75370215e-05)
    list(4.79425e-09 0.0188114501 0 1.7533885e-05)
    list(4.79625e-09 0.0188114635 0 1.75311657e-05)
    list(4.79825e-09 0.018811477 0 1.75287813e-05)
    list(4.8e-09 0.0188114889 0 1.75262592e-05)
    list(4.80075e-09 0.0189082381 0.15 6.61429126e-06)
    list(4.80275e-09 0.0191745011 0.55 -6.25726196e-06)
    list(4.80475e-09 0.0196434076 0.95 2.00379703e-05)
    list(4.80535e-09 0.0197378842 1 2.75163401e-05)
    list(4.80725e-09 0.0196871568 1 1.24349142e-05)
    list(4.80925e-09 0.0195660569 1 1.03752114e-05)
    list(4.81125e-09 0.0194401847 1 9.82849417e-06)
    list(4.81325e-09 0.0193146659 1 9.43286367e-06)
    list(4.81525e-09 0.0191898991 1 9.06645526e-06)
    list(4.81725e-09 0.0190659114 1 8.71237989e-06)
    list(4.81925e-09 0.0189427009 1 8.36224985e-06)
    list(4.82125e-09 0.0188202632 1 8.00452663e-06)
    list(4.82325e-09 0.0186985939 1 7.6167104e-06)
    list(4.82525e-09 0.0185776886 1 7.15323803e-06)
    list(4.82725e-09 0.018457543 1 6.55288805e-06)
    list(4.82925e-09 0.018338153 1 5.81119732e-06)
    list(4.83015e-09 0.0182486075 0.97 2.23610373e-05)
    list(4.83175e-09 0.0176703727 0.65 5.93846375e-06)
    list(4.83375e-09 0.0171732968 0.25 5.26361107e-05)
    list(4.83505e-09 0.0170023285 0 4.74727168e-05)
    list(4.83625e-09 0.0170023202 0 2.40974892e-05)
    list(4.83825e-09 0.0170023267 0 1.99454838e-05)
    list(4.84025e-09 0.0170023331 0 1.93697255e-05)
    list(4.84225e-09 0.0170023394 0 1.9108949e-05)
    list(4.84425e-09 0.0170023463 0 1.89624306e-05)
    list(4.84625e-09 0.0170023538 0 1.88625552e-05)
    list(4.84825e-09 0.0170023622 0 1.87750077e-05)
    list(4.85025e-09 0.0170023712 0 1.8680758e-05)
    list(4.85225e-09 0.0170023808 0 1.8570573e-05)
    list(4.85425e-09 0.0170023909 0 1.84441999e-05)
    list(4.85625e-09 0.0170024015 0 1.8308839e-05)
    list(4.85825e-09 0.0170024124 0 1.81749624e-05)
    list(4.86025e-09 0.0170024237 0 1.80517674e-05)
    list(4.86225e-09 0.0170024352 0 1.79447975e-05)
    list(4.86425e-09 0.017002447 0 1.78558877e-05)
    list(4.86625e-09 0.017002459 0 1.77842634e-05)
    list(4.86825e-09 0.0170024713 0 1.77277728e-05)
    list(4.87025e-09 0.0170024838 0 1.76838018e-05)
    list(4.87225e-09 0.0170024964 0 1.76498102e-05)
    list(4.87425e-09 0.0170025093 0 1.76235819e-05)
    list(4.87625e-09 0.0170025223 0 1.76032993e-05)
    list(4.87825e-09 0.0170025355 0 1.75875284e-05)
    list(4.88025e-09 0.0170025488 0 1.75751652e-05)
    list(4.88225e-09 0.0170025623 0 1.75653732e-05)
    list(4.88425e-09 0.0170025759 0 1.7557525e-05)
    list(4.88625e-09 0.0170025896 0 1.75511524e-05)
    list(4.88825e-09 0.0170026035 0 1.75459071e-05)
    list(4.89025e-09 0.0170026175 0 1.75415299e-05)
    list(4.89225e-09 0.0170026316 0 1.75378274e-05)
    list(4.89425e-09 0.0170026458 0 1.75346551e-05)
    list(4.89625e-09 0.0170026601 0 1.7531904e-05)
    list(4.89825e-09 0.0170026746 0 1.75294916e-05)
    list(4.9e-09 0.0170026873 0 1.75269386e-05)
    list(4.90075e-09 0.0170996019 0.15 6.60873995e-06)
    list(4.90275e-09 0.0173692221 0.55 -6.20098431e-06)
    list(4.90475e-09 0.0178505699 0.95 1.9923521e-05)
    list(4.90535e-09 0.0179486895 1 2.75340261e-05)
    list(4.90725e-09 0.0179093383 1 1.22663263e-05)
    list(4.90925e-09 0.0177993989 1 1.02174712e-05)
    list(4.91125e-09 0.0176846096 1 9.68723909e-06)
    list(4.91325e-09 0.0175701106 1 9.30625958e-06)
    list(4.91525e-09 0.0174562993 1 8.95283438e-06)
    list(4.91725e-09 0.0173432031 1 8.61029868e-06)
    list(4.91925e-09 0.01723082 1 8.27043617e-06)
    list(4.92125e-09 0.0171191462 1 7.92186443e-06)
    list(4.92325e-09 0.0170081775 1 7.54224257e-06)
    list(4.92525e-09 0.0168979097 1 7.08617408e-06)
    list(4.92725e-09 0.016788339 1 6.49251828e-06)
    list(4.92925e-09 0.0166794614 1 5.7567173e-06)
    list(4.93015e-09 0.0165945857 0.97 2.23552014e-05)
    list(4.93175e-09 0.0160229386 0.65 5.56523779e-06)
    list(4.93375e-09 0.0155282184 0.25 5.23445476e-05)
    list(4.93505e-09 0.015357024 0 4.7435176e-05)
    list(4.93625e-09 0.0153570162 0 2.40876603e-05)
    list(4.93825e-09 0.0153570236 0 1.99570684e-05)
    list(4.94025e-09 0.0153570308 0 1.93814909e-05)
    list(4.94225e-09 0.0153570379 0 1.91196794e-05)
    list(4.94425e-09 0.0153570456 0 1.89718755e-05)
    list(4.94625e-09 0.0153570539 0 1.88706107e-05)
    list(4.94825e-09 0.0153570631 0 1.87816228e-05)
    list(4.95025e-09 0.0153570729 0 1.86859332e-05)
    list(4.95225e-09 0.0153570834 0 1.85744098e-05)
    list(4.95425e-09 0.0153570943 0 1.84469343e-05)
    list(4.95625e-09 0.0153571057 0 1.83107977e-05)
    list(4.95825e-09 0.0153571175 0 1.8176467e-05)
    list(4.96025e-09 0.0153571296 0 1.80530614e-05)
    list(4.96225e-09 0.0153571419 0 1.79460267e-05)
    list(4.96425e-09 0.0153571545 0 1.78571186e-05)
    list(4.96625e-09 0.0153571674 0 1.77855123e-05)
    list(4.96825e-09 0.0153571805 0 1.77290309e-05)
    list(4.97025e-09 0.0153571938 0 1.76850514e-05)
    list(4.97225e-09 0.0153572074 0 1.76510335e-05)
    list(4.97425e-09 0.0153572211 0 1.76247647e-05)
    list(4.97625e-09 0.0153572349 0 1.76044323e-05)
    list(4.97825e-09 0.015357249 0 1.75886064e-05)
    list(4.98025e-09 0.0153572632 0 1.75761866e-05)
    list(4.98225e-09 0.0153572775 0 1.75663389e-05)
    list(4.98425e-09 0.015357292 0 1.75584374e-05)
    list(4.98625e-09 0.0153573066 0 1.75520151e-05)
    list(4.98825e-09 0.0153573214 0 1.75467242e-05)
    list(4.99025e-09 0.0153573362 0 1.75423057e-05)
    list(4.99225e-09 0.0153573512 0 1.75385663e-05)
    list(4.99425e-09 0.0153573663 0 1.7535361e-05)
    list(4.99625e-09 0.0153573816 0 1.75325808e-05)
    list(4.99825e-09 0.0153573969 0 1.75301428e-05)
    list(5e-09 0.0153574104 0 1.75275614e-05)
    list(5.00075e-09 0.0154544747 0.15 6.60360796e-06)
    list(5.00275e-09 0.0157272287 0.55 -6.15110744e-06)
    list(5.00475e-09 0.0162196786 0.95 1.98164876e-05)
    list(5.00535e-09 0.0163212556 1 2.75447786e-05)
    list(5.00725e-09 0.0162923487 1 1.21081662e-05)
    list(5.00925e-09 0.016192626 1 1.00689412e-05)
    list(5.01125e-09 0.0160879778 1 9.55367938e-06)
    list(5.01325e-09 0.0159835607 1 9.18606217e-06)
    list(5.01525e-09 0.0158797716 1 8.84452424e-06)
    list(5.01725e-09 0.0157766378 1 8.51259456e-06)
    list(5.01925e-09 0.0156741577 1 8.18220497e-06)
    list(5.02125e-09 0.0155723278 1 7.84210885e-06)
    list(5.02325e-09 0.0154711442 1 7.47010515e-06)
    list(5.02525e-09 0.015370603 1 7.02094568e-06)
    list(5.02725e-09 0.0152707008 1 6.4335595e-06)
    list(5.02925e-09 0.015171434 1 5.70329608e-06)
    list(5.03015e-09 0.015090832 0.97 2.23499268e-05)
    list(5.03175e-09 0.0145252272 0.65 5.2267739e-06)
    list(5.03375e-09 0.0140326963 0.25 5.20786083e-05)
    list(5.03505e-09 0.0138612975 0 4.74005132e-05)
    list(5.03625e-09 0.0138612903 0 2.40788171e-05)
    list(5.03825e-09 0.0138612984 0 1.996765e-05)
    list(5.04025e-09 0.0138613065 0 1.93922251e-05)
    list(5.04225e-09 0.0138613144 0 1.91294656e-05)
    list(5.04425e-09 0.0138613228 0 1.89804862e-05)
    list(5.04625e-09 0.013861332 0 1.8877951e-05)
    list(5.04825e-09 0.013861342 0 1.87876459e-05)
    list(5.05025e-09 0.0138613526 0 1.86906406e-05)
    list(5.05225e-09 0.0138613638 0 1.85778964e-05)
    list(5.05425e-09 0.0138613756 0 1.84494183e-05)
    list(5.05625e-09 0.0138613878 0 1.83125789e-05)
    list(5.05825e-09 0.0138614004 0 1.81778387e-05)
    list(5.06025e-09 0.0138614133 0 1.80542444e-05)
    list(5.06225e-09 0.0138614264 0 1.79471527e-05)
    list(5.06425e-09 0.0138614399 0 1.7858247e-05)
    list(5.06625e-09 0.0138614536 0 1.77866575e-05)
    list(5.06825e-09 0.0138614675 0 1.77301844e-05)
    list(5.07025e-09 0.0138614817 0 1.76861969e-05)
    list(5.07225e-09 0.013861496 0 1.76521548e-05)
    list(5.07425e-09 0.0138615106 0 1.76258488e-05)
    list(5.07625e-09 0.0138615253 0 1.76054706e-05)
    list(5.07825e-09 0.0138615402 0 1.75895943e-05)
    list(5.08025e-09 0.0138615552 0 1.75771226e-05)
    list(5.08225e-09 0.0138615704 0 1.75672237e-05)
    list(5.08425e-09 0.0138615858 0 1.75592735e-05)
    list(5.08625e-09 0.0138616012 0 1.75528057e-05)
    list(5.08825e-09 0.0138616168 0 1.75474731e-05)
    list(5.09025e-09 0.0138616326 0 1.75430169e-05)
    list(5.09225e-09 0.0138616484 0 1.75392435e-05)
    list(5.09425e-09 0.0138616644 0 1.75360081e-05)
    list(5.09625e-09 0.0138616805 0 1.75332012e-05)
    list(5.09825e-09 0.0138616967 0 1.75307397e-05)
    list(5.1e-09 0.013861711 0 1.75281322e-05)
    list(5.10075e-09 0.0139589107 0.15 6.59887319e-06)
    list(5.10275e-09 0.014234581 0.55 -6.10689983e-06)
    list(5.10475e-09 0.0147371196 0.95 1.97161256e-05)
    list(5.10535e-09 0.0148418432 1 2.75542064e-05)
    list(5.10725e-09 0.0148224735 1 1.19645352e-05)
    list(5.10925e-09 0.0147320869 1 9.93392219e-06)
    list(5.11125e-09 0.0146367051 1 9.43225629e-06)
    list(5.11325e-09 0.0145414997 1 9.07678144e-06)
    list(5.11525e-09 0.014446867 1 8.74604664e-06)
    list(5.11725e-09 0.0143528343 1 8.42375634e-06)
    list(5.11925e-09 0.0142594005 1 8.1019769e-06)
    list(5.12125e-09 0.0141665623 1 7.76958527e-06)
    list(5.12325e-09 0.014074316 1 7.40450795e-06)
    list(5.12525e-09 0.0139826583 1 6.96163241e-06)
    list(5.12725e-09 0.0138915857 1 6.37995096e-06)
    list(5.12925e-09 0.0138010952 1 5.65472585e-06)
    list(5.13015e-09 0.0137243963 0.97 2.23450746e-05)
    list(5.13175e-09 0.0131643258 0.65 4.91984727e-06)
    list(5.13375e-09 0.012673824 0.25 5.18361885e-05)
    list(5.13505e-09 0.0125022405 0 4.73685695e-05)
    list(5.13625e-09 0.0125022337 0 2.40708566e-05)
    list(5.13825e-09 0.0125022427 0 1.99764095e-05)
    list(5.14025e-09 0.0125022516 0 1.94020811e-05)
    list(5.14225e-09 0.0125022602 0 1.91384583e-05)
    list(5.14425e-09 0.0125022695 0 1.89883946e-05)
    list(5.14625e-09 0.0125022794 0 1.88846891e-05)
    list(5.14825e-09 0.0125022902 0 1.87931709e-05)
    list(5.15025e-09 0.0125023016 0 1.86949545e-05)
    list(5.15225e-09 0.0125023136 0 1.85810885e-05)
    list(5.15425e-09 0.0125023261 0 1.84516916e-05)
    list(5.15625e-09 0.0125023391 0 1.83142105e-05)
    list(5.15825e-09 0.0125023525 0 1.81790984e-05)
    list(5.16025e-09 0.0125023662 0 1.80553342e-05)
    list(5.16225e-09 0.0125023802 0 1.79481923e-05)
    list(5.16425e-09 0.0125023944 0 1.78592903e-05)
    list(5.16625e-09 0.0125024089 0 1.77877169e-05)
    list(5.16825e-09 0.0125024236 0 1.77312517e-05)
    list(5.17025e-09 0.0125024386 0 1.76872568e-05)
    list(5.17225e-09 0.0125024538 0 1.76531921e-05)
    list(5.17425e-09 0.0125024691 0 1.76268517e-05)
    list(5.17625e-09 0.0125024847 0 1.76064311e-05)
    list(5.17825e-09 0.0125025004 0 1.75905082e-05)
    list(5.18025e-09 0.0125025163 0 1.75779884e-05)
    list(5.18225e-09 0.0125025323 0 1.75680422e-05)
    list(5.18425e-09 0.0125025484 0 1.75600468e-05)
    list(5.18625e-09 0.0125025647 0 1.75535369e-05)
    list(5.18825e-09 0.0125025812 0 1.75481656e-05)
    list(5.19025e-09 0.0125025977 0 1.75436743e-05)
    list(5.19225e-09 0.0125026144 0 1.75398696e-05)
    list(5.19425e-09 0.0125026312 0 1.75366061e-05)
    list(5.19625e-09 0.0125026482 0 1.75337744e-05)
    list(5.19825e-09 0.0125026652 0 1.7531291e-05)
    list(5.2e-09 0.0125026803 0 1.75286592e-05)
    list(5.20075e-09 0.0126000026 0.15 6.59451284e-06)
    list(5.20275e-09 0.0128783792 0.55 -6.06770237e-06)
    list(5.20475e-09 0.0133900809 0.95 1.96223157e-05)
    list(5.20535e-09 0.0134975386 1 2.75634038e-05)
    list(5.20725e-09 0.0134870009 1 1.18354172e-05)
    list(5.20925e-09 0.0134051335 1 9.81244544e-06)
    list(5.21125e-09 0.0133182092 1 9.32324618e-06)
    list(5.21325e-09 0.0132314112 1 8.97880037e-06)
    list(5.21525e-09 0.0131451349 1 8.65785957e-06)
    list(5.21725e-09 0.013059408 1 8.34429759e-06)
    list(5.21925e-09 0.0129742294 1 8.03030562e-06)
    list(5.22125e-09 0.012889596 1 7.70487473e-06)
    list(5.22325e-09 0.0128055046 1 7.34604905e-06)
    list(5.22525e-09 0.012721952 1 6.90884115e-06)
    list(5.22725e-09 0.0126389352 1 6.3323017e-06)
    list(5.22925e-09 0.0125564513 1 5.61161192e-06)
    list(5.23015e-09 0.0124833123 0.97 2.2340592e-05)
    list(5.23175e-09 0.0119283044 0.65 4.64157379e-06)
    list(5.23375e-09 0.0114396783 0.25 5.16153732e-05)
    list(5.23505e-09 0.0112679281 0 4.73391826e-05)
    list(5.23625e-09 0.0112679218 0 2.40636865e-05)
    list(5.23825e-09 0.0112679315 0 1.99852217e-05)
    list(5.24025e-09 0.0112679411 0 1.94109921e-05)
    list(5.24225e-09 0.0112679506 0 1.9146577e-05)
    list(5.24425e-09 0.0112679605 0 1.89955333e-05)
    list(5.24625e-09 0.0112679713 0 1.88907688e-05)
    list(5.24825e-09 0.0112679827 0 1.87981526e-05)
    list(5.25025e-09 0.0112679949 0 1.86988407e-05)
    list(5.25225e-09 0.0112680077 0 1.85839617e-05)
    list(5.25425e-09 0.011268021 0 1.8453737e-05)
    list(5.25625e-09 0.0112680347 0 1.83156794e-05)
    list(5.25825e-09 0.0112680489 0 1.81802342e-05)
    list(5.26025e-09 0.0112680633 0 1.80563184e-05)
    list(5.26225e-09 0.0112680781 0 1.79491323e-05)
    list(5.26425e-09 0.0112680931 0 1.78602339e-05)
    list(5.26625e-09 0.0112681084 0 1.77886748e-05)
    list(5.26825e-09 0.0112681239 0 1.77322165e-05)
    list(5.27025e-09 0.0112681396 0 1.76882146e-05)
    list(5.27225e-09 0.0112681556 0 1.76541294e-05)
    list(5.27425e-09 0.0112681717 0 1.76277577e-05)
    list(5.27625e-09 0.011268188 0 1.76072988e-05)
    list(5.27825e-09 0.0112682046 0 1.75913336e-05)
    list(5.28025e-09 0.0112682212 0 1.75787705e-05)
    list(5.28225e-09 0.011268238 0 1.75687816e-05)
    list(5.28425e-09 0.011268255 0 1.75607455e-05)
    list(5.28625e-09 0.0112682721 0 1.75541977e-05)
    list(5.28825e-09 0.0112682893 0 1.75487916e-05)
    list(5.29025e-09 0.0112683067 0 1.75442687e-05)
    list(5.29225e-09 0.0112683242 0 1.75404357e-05)
    list(5.29425e-09 0.0112683418 0 1.75371471e-05)
    list(5.29625e-09 0.0112683596 0 1.7534293e-05)
    list(5.29825e-09 0.0112683775 0 1.753179e-05)
    list(5.3e-09 0.0112683932 0 1.75291363e-05)
    list(5.30075e-09 0.0113658264 0.15 6.59050462e-06)
    list(5.30275e-09 0.0116467081 0.55 -6.03292299e-06)
    list(5.30475e-09 0.0121667023 0.95 1.95343868e-05)
    list(5.30535e-09 0.0122765627 1 2.75722093e-05)
    list(5.30725e-09 0.012274174 1 1.19285063e-05)
    list(5.30925e-09 0.0122001064 1 9.88538691e-06)
    list(5.31125e-09 0.0121208961 1 9.38769798e-06)
    list(5.31325e-09 0.0120417638 1 9.03616753e-06)
    list(5.31525e-09 0.0119631066 1 8.70892939e-06)
    list(5.31725e-09 0.011884952 1 8.38976628e-06)
    list(5.31925e-09 0.0118072993 1 8.07080087e-06)
    list(5.32125e-09 0.0117301457 1 7.74096796e-06)
    list(5.32325e-09 0.0116534883 1 7.37827591e-06)
    list(5.32525e-09 0.011577324 1 6.9377236e-06)
    list(5.32725e-09 0.0115016502 1 6.35830031e-06)
    list(5.32925e-09 0.011426464 1 5.63500949e-06)
    list(5.33015e-09 0.0113565591 0.97 2.26161601e-05)
    list(5.33175e-09 0.010806183 0.65 4.77222569e-06)
    list(5.33375e-09 0.0103192884 0.25 5.17477952e-05)
    list(5.33505e-09 0.0101473877 0 4.72917708e-05)
    list(5.33625e-09 0.0101473818 0 2.40429008e-05)
    list(5.33825e-09 0.0101473923 0 1.99808665e-05)
    list(5.34025e-09 0.0101474026 0 1.94084028e-05)
    list(5.34225e-09 0.0101474128 0 1.91447204e-05)
    list(5.34425e-09 0.0101474235 0 1.89940428e-05)
    list(5.34625e-09 0.010147435 0 1.88894015e-05)
    list(5.34825e-09 0.0101474472 0 1.87967249e-05)
    list(5.35025e-09 0.0101474601 0 1.86972271e-05)
    list(5.35225e-09 0.0101474736 0 1.85821273e-05)
    list(5.35425e-09 0.0101474876 0 1.84517558e-05)
    list(5.35625e-09 0.0101475021 0 1.83136973e-05)
    list(5.35825e-09 0.010147517 0 1.81784003e-05)
    list(5.36025e-09 0.0101475321 0 1.80547347e-05)
    list(5.36225e-09 0.0101475476 0 1.79478414e-05)
    list(5.36425e-09 0.0101475634 0 1.78592318e-05)
    list(5.36625e-09 0.0101475794 0 1.77879305e-05)
    list(5.36825e-09 0.0101475957 0 1.77316879e-05)
    list(5.37025e-09 0.0101476122 0 1.76878588e-05)
    list(5.37225e-09 0.0101476289 0 1.76539078e-05)
    list(5.37425e-09 0.0101476458 0 1.76276382e-05)
    list(5.37625e-09 0.0101476629 0 1.76072556e-05)
    list(5.37825e-09 0.0101476801 0 1.75913467e-05)
    list(5.38025e-09 0.0101476975 0 1.75788244e-05)
    list(5.38225e-09 0.0101477151 0 1.75688647e-05)
    list(5.38425e-09 0.0101477329 0 1.7560849e-05)
    list(5.38625e-09 0.0101477507 0 1.75543151e-05)
    list(5.38825e-09 0.0101477687 0 1.7548918e-05)
    list(5.39025e-09 0.0101477869 0 1.75444006e-05)
    list(5.39225e-09 0.0101478052 0 1.75405703e-05)
    list(5.39425e-09 0.0101478236 0 1.75372824e-05)
    list(5.39625e-09 0.0101478421 0 1.75344277e-05)
    list(5.39825e-09 0.0101478608 0 1.7531923e-05)
    list(5.4e-09 0.0101478772 0 1.75292656e-05)
    list(5.40075e-09 0.0102454106 0.15 6.58683218e-06)
    list(5.40275e-09 0.0105286061 0.55 -6.00197756e-06)
    list(5.40475e-09 0.0110560884 0.95 1.94519917e-05)
    list(5.40535e-09 0.0111681525 1 2.75800061e-05)
    list(5.40725e-09 0.0111731977 1 1.20594739e-05)
    list(5.40925e-09 0.0111062381 1 9.9917855e-06)
    list(5.41125e-09 0.0110340568 1 9.48215388e-06)
    list(5.41325e-09 0.0109619092 1 9.12042055e-06)
    list(5.41525e-09 0.0108901937 1 8.78410737e-06)
    list(5.41725e-09 0.0108189379 1 8.45687005e-06)
    list(5.41925e-09 0.0107481416 1 8.13072927e-06)
    list(5.42125e-09 0.010677802 1 7.79453329e-06)
    list(5.42325e-09 0.0106079164 1 7.42622641e-06)
    list(5.42525e-09 0.0105384821 1 6.98076712e-06)
    list(5.42725e-09 0.0104694965 1 6.39706349e-06)
    list(5.42925e-09 0.0104009573 1 5.66993315e-06)
    list(5.43015e-09 0.0103339898 0.97 2.31318737e-05)
    list(5.43175e-09 0.00978783885 0.65 5.25318636e-06)
    list(5.43375e-09 0.00930254336 0.25 5.21829435e-05)
    list(5.43505e-09 0.00913050668 0 4.72292228e-05)
    list(5.43625e-09 0.00913050127 0 2.40102601e-05)
    list(5.43825e-09 0.00913051246 0 1.99652072e-05)
    list(5.44025e-09 0.00913052351 0 1.93959262e-05)
    list(5.44225e-09 0.00913053438 0 1.91342824e-05)
    list(5.44425e-09 0.00913054578 0 1.8985125e-05)
    list(5.44625e-09 0.00913055792 0 1.88816228e-05)
    list(5.44825e-09 0.00913057083 0 1.87897787e-05)
    list(5.45025e-09 0.00913058442 0 1.86908789e-05)
    list(5.45225e-09 0.00913059863 0 1.85762416e-05)
    list(5.45425e-09 0.00913061336 0 1.84463101e-05)
    list(5.45625e-09 0.00913062853 0 1.8308746e-05)
    list(5.45825e-09 0.00913064408 0 1.81740103e-05)
    list(5.46025e-09 0.00913065997 0 1.80509388e-05)
    list(5.46225e-09 0.00913067616 0 1.79446264e-05)
    list(5.46425e-09 0.00913069263 0 1.78565494e-05)
    list(5.46625e-09 0.00913070936 0 1.77857139e-05)
    list(5.46825e-09 0.00913072634 0 1.77298656e-05)
    list(5.47025e-09 0.00913074354 0 1.76863634e-05)
    list(5.47225e-09 0.00913076097 0 1.76526796e-05)
    list(5.47425e-09 0.00913077859 0 1.76266269e-05)
    list(5.47625e-09 0.0091307964 0 1.76064194e-05)
    list(5.47825e-09 0.00913081438 0 1.75906516e-05)
    list(5.48025e-09 0.00913083254 0 1.75782429e-05)
    list(5.48225e-09 0.00913085085 0 1.75683747e-05)
    list(5.48425e-09 0.00913086931 0 1.75604325e-05)
    list(5.48625e-09 0.00913088792 0 1.75539575e-05)
    list(5.48825e-09 0.00913090666 0 1.75486077e-05)
    list(5.49025e-09 0.00913092555 0 1.7544128e-05)
    list(5.49225e-09 0.00913094456 0 1.75403276e-05)
    list(5.49425e-09 0.00913096371 0 1.75370633e-05)
    list(5.49625e-09 0.00913098298 0 1.7534227e-05)
    list(5.49825e-09 0.00913100238 0 1.75317364e-05)
    list(5.5e-09 0.00913101945 0 1.75290913e-05)
    list(5.50075e-09 0.00922864361 0.15 6.58347264e-06)
    list(5.50275e-09 0.00951397167 0.55 -5.97441215e-06)
    list(5.50475e-09 0.0100482457 0.95 1.93756593e-05)
    list(5.50535e-09 0.0101623109 1 2.75869421e-05)
    list(5.50725e-09 0.0101741215 1 1.21786061e-05)
    list(5.50925e-09 0.0101136347 1 1.00884497e-05)
    list(5.51125e-09 0.0100478537 1 9.56796035e-06)
    list(5.51325e-09 0.00998206578 1 9.196957e-06)
    list(5.51525e-09 0.00991667036 1 8.85239903e-06)
    list(5.51725e-09 0.00985169557 1 8.51782633e-06)
    list(5.51925e-09 0.0097871411 1 8.18516696e-06)
    list(5.52125e-09 0.00972300455 1 7.84319058e-06)
    list(5.52325e-09 0.00965928338 1 7.46978349e-06)
    list(5.52525e-09 0.00959597513 1 7.0198679e-06)
    list(5.52725e-09 0.00953307744 1 6.43227805e-06)
    list(5.52925e-09 0.00947058808 1 5.70166152e-06)
    list(5.53015e-09 0.00940629424 0.97 2.36004785e-05)
    list(5.53175e-09 0.00886399231 0.65 5.69037379e-06)
    list(5.53375e-09 0.00838016772 0.25 5.25779587e-05)
    list(5.53505e-09 0.00820800829 0 4.71722583e-05)
    list(5.53625e-09 0.00820800328 0 2.39809176e-05)
    list(5.53825e-09 0.00820801515 0 1.99518504e-05)
    list(5.54025e-09 0.00820802687 0 1.9384527e-05)
    list(5.54225e-09 0.0082080384 0 1.91247287e-05)
    list(5.54425e-09 0.00820805046 0 1.897696e-05)
    list(5.54625e-09 0.00820806326 0 1.88744996e-05)
    list(5.54825e-09 0.00820807683 0 1.87834191e-05)
    list(5.55025e-09 0.00820809108 0 1.86850704e-05)
    list(5.55225e-09 0.00820810595 0 1.85708616e-05)
    list(5.55425e-09 0.00820812134 0 1.84413376e-05)
    list(5.55625e-09 0.00820813717 0 1.83042289e-05)
    list(5.55825e-09 0.00820815339 0 1.81700071e-05)
    list(5.56025e-09 0.00820816994 0 1.80474773e-05)
    list(5.56225e-09 0.0082081868 0 1.79416932e-05)
    list(5.56425e-09 0.00820820394 0 1.78541e-05)
    list(5.56625e-09 0.00820822135 0 1.77836874e-05)
    list(5.56825e-09 0.008208239 0 1.77281971e-05)
    list(5.57025e-09 0.00820825689 0 1.76849918e-05)
    list(5.57225e-09 0.00820827499 0 1.7651551e-05)
    list(5.57425e-09 0.00820829329 0 1.76256956e-05)
    list(5.57625e-09 0.00820831179 0 1.76056476e-05)
    list(5.57825e-09 0.00820833046 0 1.75900086e-05)
    list(5.58025e-09 0.0082083493 0 1.75777038e-05)
    list(5.58225e-09 0.00820836831 0 1.75679192e-05)
    list(5.58425e-09 0.00820838746 0 1.75600445e-05)
    list(5.58625e-09 0.00820840676 0 1.75536237e-05)
    list(5.58825e-09 0.00820842621 0 1.75483175e-05)
    list(5.59025e-09 0.00820844579 0 1.75438726e-05)
    list(5.59225e-09 0.00820846551 0 1.75400999e-05)
    list(5.59425e-09 0.00820848535 0 1.75368575e-05)
    list(5.59625e-09 0.00820850533 0 1.75340384e-05)
    list(5.59825e-09 0.00820852544 0 1.7531561e-05)
    list(5.6e-09 0.00820854313 0 1.75289277e-05)
    list(5.60075e-09 0.00830624933 0.15 6.58039812e-06)
    list(5.60275e-09 0.00859353902 0.55 -5.94987915e-06)
    list(5.60475e-09 0.00913397107 0.95 1.9305103e-05)
    list(5.60535e-09 0.0092498526 1 2.75931163e-05)
    list(5.60725e-09 0.00926781636 1 1.2286919e-05)
    list(5.60925e-09 0.00921322009 1 1.01762398e-05)
    list(5.61125e-09 0.00915326296 1 9.6458834e-06)
    list(5.61325e-09 0.00909326163 1 9.26646048e-06)
    list(5.61525e-09 0.00903361672 1 8.91441451e-06)
    list(5.61725e-09 0.00897435648 1 8.57317991e-06)
    list(5.61925e-09 0.00891548082 1 8.23460056e-06)
    list(5.62125e-09 0.00885698751 1 7.88737484e-06)
    list(5.62325e-09 0.00879887423 1 7.50933653e-06)
    list(5.62525e-09 0.00874113873 1 7.05537517e-06)
    list(5.62725e-09 0.00868377883 1 6.46425799e-06)
    list(5.62925e-09 0.00862679251 1 5.73047704e-06)
    list(5.63015e-09 0.00856493075 0.97 2.40260771e-05)
    list(5.63175e-09 0.00802613089 0.65 6.08759035e-06)
    list(5.63375e-09 0.00754366069 0.25 5.29889213e-05)
    list(5.63505e-09 0.00737139373 0 4.7125122e-05)
    list(5.63625e-09 0.00737138909 0 2.39539781e-05)
    list(5.63825e-09 0.00737140159 0 1.99384912e-05)
    list(5.64025e-09 0.00737141392 0 1.93740809e-05)
    list(5.64225e-09 0.00737142607 0 1.91160814e-05)
    list(5.64425e-09 0.00737143874 0 1.89696099e-05)
    list(5.64625e-09 0.00737145215 0 1.88680947e-05)
    list(5.64825e-09 0.00737146632 0 1.87776862e-05)
    list(5.65025e-09 0.00737148119 0 1.86798058e-05)
    list(5.65225e-09 0.00737149667 0 1.8565953e-05)
    list(5.65425e-09 0.00737151267 0 1.84367743e-05)
    list(5.65625e-09 0.00737152911 0 1.83000677e-05)
    list(5.65825e-09 0.00737154594 0 1.8166314e-05)
    list(5.66025e-09 0.00737156311 0 1.80442861e-05)
    list(5.66225e-09 0.00737158059 0 1.7938996e-05)
    list(5.66425e-09 0.00737159835 0 1.78518565e-05)
    list(5.66625e-09 0.00737161638 0 1.77818407e-05)
    list(5.66825e-09 0.00737163466 0 1.77266859e-05)
    list(5.67025e-09 0.00737165317 0 1.7683758e-05)
    list(5.67225e-09 0.0073716719 0 1.76505434e-05)
    list(5.67425e-09 0.00737169083 0 1.76248709e-05)
    list(5.67625e-09 0.00737170996 0 1.76049701e-05)
    list(5.67825e-09 0.00737172927 0 1.75894493e-05)
    list(5.68025e-09 0.00737174875 0 1.75772393e-05)
    list(5.68225e-09 0.00737176839 0 1.75675307e-05)
    list(5.68425e-09 0.00737178818 0 1.75597168e-05)
    list(5.68625e-09 0.00737180813 0 1.75533447e-05)
    list(5.68825e-09 0.00737182822 0 1.75480772e-05)
    list(5.69025e-09 0.00737184844 0 1.75436632e-05)
    list(5.69225e-09 0.00737186881 0 1.75399149e-05)
    list(5.69425e-09 0.0073718893 0 1.75366916e-05)
    list(5.69625e-09 0.00737190993 0 1.75338872e-05)
    list(5.69825e-09 0.00737193069 0 1.75314212e-05)
    list(5.7e-09 0.00737194895 0 1.75287976e-05)
    list(5.70075e-09 0.00746972932 0.15 6.57754614e-06)
    list(5.70275e-09 0.00775881631 0.55 -5.92894214e-06)
    list(5.70475e-09 0.00830482609 0.95 1.92399019e-05)
    list(5.70535e-09 0.00842235545 1 2.75985151e-05)
    list(5.70725e-09 0.00844590924 1 1.23850828e-05)
    list(5.70925e-09 0.00839667208 1 1.0255685e-05)
    list(5.71125e-09 0.00834201142 1 9.71636716e-06)
    list(5.71325e-09 0.00828727234 1 9.32930284e-06)
    list(5.71525e-09 0.00823285661 1 8.97046337e-06)
    list(5.71725e-09 0.00817879266 1 8.62318679e-06)
    list(5.71925e-09 0.00812508058 1 8.27924021e-06)
    list(5.72125e-09 0.00807171833 1 7.92725703e-06)
    list(5.72325e-09 0.00801870378 1 7.54502321e-06)
    list(5.72525e-09 0.00796603484 1 7.08739872e-06)
    list(5.72725e-09 0.00791370955 1 6.49308973e-06)
    list(5.72925e-09 0.00786172607 1 5.7564462e-06)
    list(5.73015e-09 0.00780207558 0.97 2.44124585e-05)
    list(5.73175e-09 0.00726645707 0.65 6.448827e-06)
    list(5.73375e-09 0.00678522196 0.25 5.32612362e-05)
    list(5.73505e-09 0.0066128514 0 4.70735637e-05)
    list(5.73625e-09 0.00661284713 0 2.39306281e-05)
    list(5.73825e-09 0.00661286024 0 1.99273191e-05)
    list(5.74025e-09 0.00661287318 0 1.93649922e-05)
    list(5.74225e-09 0.00661288593 0 1.91083841e-05)
    list(5.74425e-09 0.0066128992 0 1.89629936e-05)
    list(5.74625e-09 0.00661291322 0 1.88623127e-05)
    list(5.74825e-09 0.00661292799 0 1.87725307e-05)
    list(5.75025e-09 0.00661294346 0 1.86751139e-05)
    list(5.75225e-09 0.00661295954 0 1.85616286e-05)
    list(5.75425e-09 0.00661297614 0 1.84327976e-05)
    list(5.75625e-09 0.00661299319 0 1.82964703e-05)
    list(5.75825e-09 0.00661301062 0 1.81631349e-05)
    list(5.76025e-09 0.00661302839 0 1.80415405e-05)
    list(5.76225e-09 0.00661304648 0 1.79366714e-05)
    list(5.76425e-09 0.00661306485 0 1.78499145e-05)
    list(5.76625e-09 0.00661308349 0 1.77802324e-05)
    list(5.76825e-09 0.00661310238 0 1.77253599e-05)
    list(5.77025e-09 0.00661312151 0 1.76826661e-05)
    list(5.77225e-09 0.00661314086 0 1.76496433e-05)
    list(5.77425e-09 0.00661316042 0 1.76241266e-05)
    list(5.77625e-09 0.00661318017 0 1.7604352e-05)
    list(5.77825e-09 0.0066132001 0 1.75889331e-05)
    list(5.78025e-09 0.0066132202 0 1.75768053e-05)
    list(5.78225e-09 0.00661324047 0 1.7567163e-05)
    list(5.78425e-09 0.00661326089 0 1.75594024e-05)
    list(5.78625e-09 0.00661328146 0 1.75530732e-05)
    list(5.78825e-09 0.00661330218 0 1.75478401e-05)
    list(5.79025e-09 0.00661332304 0 1.75434535e-05)
    list(5.79225e-09 0.00661334404 0 1.75397269e-05)
    list(5.79425e-09 0.00661336518 0 1.75365207e-05)
    list(5.79625e-09 0.00661338644 0 1.75337297e-05)
    list(5.79825e-09 0.00661340784 0 1.75312737e-05)
    list(5.8e-09 0.00661342666 1.65436123e-13 1.7528659e-05)
    list(5.80075e-09 0.00671127417 0.15 6.57502115e-06)
    list(5.80275e-09 0.00700201692 0.55 -5.90853135e-06)
    list(5.80475e-09 0.00755308976 0.95 1.91801161e-05)
    list(5.80535e-09 0.00767211464 1 2.76035269e-05)
    list(5.80725e-09 0.00770074016 1 1.24736861e-05)
    list(5.80925e-09 0.00765637924 1 1.0327193e-05)
    list(5.81125e-09 0.00760653318 1 9.77973064e-06)
    list(5.81325e-09 0.00755657711 1 9.38573113e-06)
    list(5.81525e-09 0.00750691412 1 9.02073192e-06)
    list(5.81725e-09 0.00745757282 1 8.66798216e-06)
    list(5.81925e-09 0.00740855348 1 8.31917827e-06)
    list(5.82125e-09 0.00735985422 1 7.96289385e-06)
    list(5.82325e-09 0.0073114731 1 7.5768709e-06)
    list(5.82525e-09 0.00726340822 1 7.11594214e-06)
    list(5.82725e-09 0.00721565778 1 6.51875789e-06)
    list(5.82925e-09 0.00716822011 1 5.77953805e-06)
    list(5.83015e-09 0.00711057953 0.97 2.47631091e-05)
    list(5.83175e-09 0.0065778548 0.65 6.77681156e-06)
    list(5.83375e-09 0.00609774646 0.25 5.35560977e-05)
    list(5.83505e-09 0.00592528639 0 4.70308036e-05)
    list(5.83625e-09 0.00592528244 0 2.39088433e-05)
    list(5.83825e-09 0.00592529612 0 1.99167176e-05)
    list(5.84025e-09 0.00592530961 0 1.9356544e-05)
    list(5.84225e-09 0.00592532291 0 1.91013136e-05)
    list(5.84425e-09 0.00592533672 0 1.89569503e-05)
    list(5.84625e-09 0.00592535129 0 1.8857038e-05)
    list(5.84825e-09 0.00592536661 0 1.87678171e-05)
    list(5.85025e-09 0.00592538262 0 1.86708037e-05)
    list(5.85225e-09 0.00592539925 0 1.85576326e-05)
    list(5.85425e-09 0.0059254164 0 1.84291032e-05)
    list(5.85625e-09 0.00592543399 0 1.82931155e-05)
    list(5.85825e-09 0.00592545198 0 1.81601646e-05)
    list(5.86025e-09 0.00592547031 0 1.80389753e-05)
    list(5.86225e-09 0.00592548895 0 1.79345008e-05)
    list(5.86425e-09 0.00592550788 0 1.78481049e-05)
    list(5.86625e-09 0.00592552708 0 1.77787377e-05)
    list(5.86825e-09 0.00592554653 0 1.77241315e-05)
    list(5.87025e-09 0.00592556622 0 1.76816582e-05)
    list(5.87225e-09 0.00592558614 0 1.76488155e-05)
    list(5.87425e-09 0.00592560626 0 1.76234449e-05)
    list(5.87625e-09 0.00592562658 0 1.76037882e-05)
    list(5.87825e-09 0.00592564708 0 1.75884643e-05)
    list(5.88025e-09 0.00592566775 0 1.75764129e-05)
    list(5.88225e-09 0.00592568859 0 1.75668321e-05)
    list(5.88425e-09 0.00592570959 0 1.75591209e-05)
    list(5.88625e-09 0.00592573074 0 1.75528313e-05)
    list(5.88825e-09 0.00592575204 0 1.75476299e-05)
    list(5.89025e-09 0.00592577348 0 1.75432685e-05)
    list(5.89225e-09 0.00592579506 0 1.75395619e-05)
    list(5.89425e-09 0.00592581677 0 1.75363715e-05)
    list(5.89625e-09 0.00592583862 0 1.75335926e-05)
    list(5.89825e-09 0.00592586061 0 1.75311461e-05)
    list(5.9e-09 0.00592587994 0 1.75285396e-05)
    list(5.90075e-09 0.00602378814 0.15 6.57268084e-06)
    list(5.90275e-09 0.00631604352 0.55 -5.89116324e-06)
    list(5.90475e-09 0.00687170028 0.95 1.91250428e-05)
    list(5.90535e-09 0.006992081 1 2.7607913e-05)
    list(5.90725e-09 0.00702529794 1 1.24944623e-05)
    list(5.90925e-09 0.00698537828 1 1.03358039e-05)
    list(5.91125e-09 0.00693990723 1 9.78665053e-06)
    list(5.91325e-09 0.00689429652 1 9.39164519e-06)
    list(5.91525e-09 0.00684895115 1 9.02578177e-06)
    list(5.91725e-09 0.00680389999 1 8.67227401e-06)
    list(5.91925e-09 0.00675914345 1 8.32280869e-06)
    list(5.92125e-09 0.00671467984 1 7.96595509e-06)
    list(5.92325e-09 0.00667050737 1 7.57946012e-06)
    list(5.92525e-09 0.0066266243 1 7.11817197e-06)
    list(5.92725e-09 0.00658302902 1 6.52072604e-06)
    list(5.92925e-09 0.00653972 1 5.78125559e-06)
    list(5.93015e-09 0.00648390541 0.97 2.50821155e-05)
    list(5.93175e-09 0.00595381137 0.65 7.07523311e-06)
    list(5.93375e-09 0.00547472856 0.25 5.3824296e-05)
    list(5.93505e-09 0.00530218826 0 4.69918544e-05)
    list(5.93625e-09 0.0053021846 0 2.38890552e-05)
    list(5.93825e-09 0.00530219879 0 1.99070545e-05)
    list(5.94025e-09 0.00530221279 0 1.93488375e-05)
    list(5.94225e-09 0.0053022266 0 1.90948607e-05)
    list(5.94425e-09 0.00530224093 0 1.89514325e-05)
    list(5.94625e-09 0.005302256 0 1.88522202e-05)
    list(5.94825e-09 0.00530227183 0 1.87635109e-05)
    list(5.95025e-09 0.00530228836 0 1.86668659e-05)
    list(5.95225e-09 0.00530230549 0 1.85539825e-05)
    list(5.95425e-09 0.00530232315 0 1.84257297e-05)
    list(5.95625e-09 0.00530234126 0 1.82900529e-05)
    list(5.95825e-09 0.00530235976 0 1.8157453e-05)
    list(5.96025e-09 0.00530237861 0 1.80366339e-05)
    list(5.96225e-09 0.00530239777 0 1.79325179e-05)
    list(5.96425e-09 0.00530241721 0 1.78464503e-05)
    list(5.96625e-09 0.00530243694 0 1.77773696e-05)
    list(5.96825e-09 0.00530245691 0 1.77230058e-05)
    list(5.97025e-09 0.00530247713 0 1.76807332e-05)
    list(5.97225e-09 0.00530249757 0 1.76480545e-05)
    list(5.97425e-09 0.00530251822 0 1.7622817e-05)
    list(5.97625e-09 0.00530253907 0 1.76032679e-05)
    list(5.97825e-09 0.0053025601 0 1.75880307e-05)
    list(5.98025e-09 0.00530258131 0 1.75760492e-05)
    list(5.98225e-09 0.00530260268 0 1.75665246e-05)
    list(5.98425e-09 0.00530262422 0 1.75588587e-05)
    list(5.98625e-09 0.0053026459 0 1.75526055e-05)
    list(5.98825e-09 0.00530266774 0 1.75474332e-05)
    list(5.99025e-09 0.00530268972 0 1.75430951e-05)
    list(5.99225e-09 0.00530271184 0 1.75394071e-05)
    list(5.99425e-09 0.0053027341 0 1.75362313e-05)
    list(5.99625e-09 0.00530275649 0 1.75334638e-05)
    list(5.99825e-09 0.00530277902 0 1.75310261e-05)
    list(6e-09 0.00530279883 0 1.75284273e-05)
    list(6.00075e-09 0.00540076192 0.15 6.57054876e-06)
    list(6.00275e-09 0.00569440086 0.55 -5.8756336e-06)
    list(6.00475e-09 0.0062541973 0.95 1.90751792e-05)
    list(6.00535e-09 0.00637581262 1 2.76118262e-05)
    list(6.00725e-09 0.00641318879 1 1.24438146e-05)
    list(6.00925e-09 0.00637731594 1 1.02779803e-05)
    list(6.01125e-09 0.00633581904 1 9.73393539e-06)
    list(6.01325e-09 0.00629415445 1 9.34418206e-06)
    list(6.01525e-09 0.00625272981 1 8.98304422e-06)
    list(6.01725e-09 0.00621157425 1 8.6337561e-06)
    list(6.01925e-09 0.00617068836 1 8.28805923e-06)
    list(6.02125e-09 0.00613007061 1 7.93457713e-06)
    list(6.02325e-09 0.00608971936 1 7.55111341e-06)
    list(6.02525e-09 0.00604963305 1 7.09257714e-06)
    list(6.02725e-09 0.00600981018 1 6.49763182e-06)
    list(6.02925e-09 0.00597024942 1 5.76036859e-06)
    list(6.03015e-09 0.0059160932 0.97 2.53724774e-05)
    list(6.03175e-09 0.00538839903 0.65 7.34676706e-06)
    list(6.03375e-09 0.00491025267 0.25 5.4068043e-05)
    list(6.03505e-09 0.00473763988 0 4.69564487e-05)
    list(6.03625e-09 0.00473763648 0 2.38711056e-05)
    list(6.03825e-09 0.00473765116 0 1.98982735e-05)
    list(6.04025e-09 0.00473766564 0 1.93418311e-05)
    list(6.04225e-09 0.00473767992 0 1.90889922e-05)
    list(6.04425e-09 0.00473769472 0 1.89464129e-05)
    list(6.04625e-09 0.00473771027 0 1.88478364e-05)
    list(6.04825e-09 0.00473772658 0 1.87595917e-05)
    list(6.05025e-09 0.00473774358 0 1.86632816e-05)
    list(6.05225e-09 0.00473776119 0 1.85506603e-05)
    list(6.05425e-09 0.00473777932 0 1.84226596e-05)
    list(6.05625e-09 0.00473779791 0 1.82872663e-05)
    list(6.05825e-09 0.00473781689 0 1.81549861e-05)
    list(6.06025e-09 0.00473783621 0 1.80345031e-05)
    list(6.06225e-09 0.00473785585 0 1.79307139e-05)
    list(6.06425e-09 0.00473787579 0 1.78449448e-05)
    list(6.06625e-09 0.00473789599 0 1.77761246e-05)
    list(6.06825e-09 0.00473791646 0 1.7721981e-05)
    list(6.07025e-09 0.00473793716 0 1.76798907e-05)
    list(6.07225e-09 0.00473795809 0 1.76473612e-05)
    list(6.07425e-09 0.00473797923 0 1.76222447e-05)
    list(6.07625e-09 0.00473800058 0 1.76027934e-05)
    list(6.07825e-09 0.0047380221 0 1.75876352e-05)
    list(6.08025e-09 0.00473804381 0 1.75757172e-05)
    list(6.08225e-09 0.00473806568 0 1.75662439e-05)
    list(6.08425e-09 0.00473808771 0 1.75586192e-05)
    list(6.08625e-09 0.0047381099 0 1.75523991e-05)
    list(6.08825e-09 0.00473813224 0 1.75472535e-05)
    list(6.09025e-09 0.00473815472 0 1.75429367e-05)
    list(6.09225e-09 0.00473817734 0 1.75392655e-05)
    list(6.09425e-09 0.00473820011 0 1.75361031e-05)
    list(6.09625e-09 0.00473822301 0 1.75333461e-05)
    list(6.09825e-09 0.00473824604 0 1.75309164e-05)
    list(6.1e-09 0.0047382663 0 1.75283248e-05)
    list(6.10075e-09 0.00483627902 0.15 6.56860876e-06)
    list(6.10275e-09 0.00513118204 0.55 -5.86172225e-06)
    list(6.10475e-09 0.00569472778 0.95 1.90294974e-05)
    list(6.10535e-09 0.00581746221 1 2.76153285e-05)
    list(6.10725e-09 0.00585861229 1 1.23980551e-05)
    list(6.10925e-09 0.00582641308 1 1.02255914e-05)
    list(6.11125e-09 0.00578852345 1 9.68616821e-06)
    list(6.11325e-09 0.00575044057 1 9.30117298e-06)
    list(6.11525e-09 0.0057125745 1 8.94431666e-06)
    list(6.11725e-09 0.00567495462 1 8.59885175e-06)
    list(6.11925e-09 0.00563758168 1 8.25656938e-06)
    list(6.12125e-09 0.0056004543 1 7.90614224e-06)
    list(6.12325e-09 0.00556357098 1 7.52542537e-06)
    list(6.12525e-09 0.00552693029 1 7.06938312e-06)
    list(6.12725e-09 0.0054905309 1 6.47670443e-06)
    list(6.12925e-09 0.00545437159 1 5.7414419e-06)
    list(6.13015e-09 0.00540172034 0.97 2.56357288e-05)
    list(6.13175e-09 0.00487619696 0.65 7.5930804e-06)
    list(6.13375e-09 0.00439890402 0.25 5.42889969e-05)
    list(6.13505e-09 0.00422622575 0 4.69242802e-05)
    list(6.13625e-09 0.00422622261 0 2.38548375e-05)
    list(6.13825e-09 0.00422623773 0 1.98903092e-05)
    list(6.14025e-09 0.00422625266 0 1.93354748e-05)
    list(6.14225e-09 0.00422626738 0 1.90836673e-05)
    list(6.14425e-09 0.00422628262 0 1.89418573e-05)
    list(6.14625e-09 0.00422629861 0 1.88438567e-05)
    list(6.14825e-09 0.00422631536 0 1.87560328e-05)
    list(6.15025e-09 0.0042263328 0 1.8660026e-05)
    list(6.15225e-09 0.00422635085 0 1.85476423e-05)
    list(6.15425e-09 0.00422636943 0 1.84198706e-05)
    list(6.15625e-09 0.00422638846 0 1.8284735e-05)
    list(6.15825e-09 0.00422640788 0 1.81527455e-05)
    list(6.16025e-09 0.00422642765 0 1.80325678e-05)
    list(6.16225e-09 0.00422644774 0 1.79290753e-05)
    list(6.16425e-09 0.00422646812 0 1.78435771e-05)
    list(6.16625e-09 0.00422648878 0 1.77749933e-05)
    list(6.16825e-09 0.00422650969 0 1.77210495e-05)
    list(6.17025e-09 0.00422653085 0 1.76791248e-05)
    list(6.17225e-09 0.00422655223 0 1.76467306e-05)
    list(6.17425e-09 0.00422657383 0 1.7621724e-05)
    list(6.17625e-09 0.00422659563 0 1.76023615e-05)
    list(6.17825e-09 0.00422661762 0 1.75872749e-05)
    list(6.18025e-09 0.00422663978 0 1.75754147e-05)
    list(6.18225e-09 0.00422666211 0 1.75659879e-05)
    list(6.18425e-09 0.00422668461 0 1.75584008e-05)
    list(6.18625e-09 0.00422670726 0 1.75522109e-05)
    list(6.18825e-09 0.00422673006 0 1.75470894e-05)
    list(6.19025e-09 0.00422675301 0 1.7542792e-05)
    list(6.19225e-09 0.0042267761 0 1.75391363e-05)
    list(6.19425e-09 0.00422679933 0 1.75359861e-05)
    list(6.19625e-09 0.0042268227 0 1.75332387e-05)
    list(6.19825e-09 0.00422684621 0 1.75308164e-05)
    list(6.2e-09 0.00422686688 0 1.75282314e-05)
    list(6.20075e-09 0.00432492449 0.15 6.56684415e-06)
    list(6.20275e-09 0.0046209812 0.55 -5.84926854e-06)
    list(6.20475e-09 0.00518792185 0.95 1.89876981e-05)
    list(6.20535e-09 0.00531167045 1 2.76184635e-05)
    list(6.20725e-09 0.00535624344 1 1.23566825e-05)
    list(6.20925e-09 0.00532737783 1 1.0178136e-05)
    list(6.21125e-09 0.0052927613 1 9.64289571e-06)
    list(6.21325e-09 0.00525792827 1 9.26221025e-06)
    list(6.21525e-09 0.00522329097 1 8.90923215e-06)
    list(6.21725e-09 0.00518887903 1 8.56723041e-06)
    list(6.21925e-09 0.00515469334 1 8.22804105e-06)
    list(6.22125e-09 0.00512073264 1 7.88038133e-06)
    list(6.22325e-09 0.00508699558 1 7.50215293e-06)
    list(6.22525e-09 0.00505348085 1 7.04837036e-06)
    list(6.22725e-09 0.00502018725 1 6.45774566e-06)
    list(6.22925e-09 0.0049871137 1 5.72429607e-06)
    list(6.23015e-09 0.00493582775 0.97 2.58743445e-05)
    list(6.23175e-09 0.00441227382 0.65 7.8163382e-06)
    list(6.23375e-09 0.00393575876 0.25 5.44890675e-05)
    list(6.23505e-09 0.00376302136 0 4.68950664e-05)
    list(6.23625e-09 0.00376301845 0 2.38400965e-05)
    list(6.23825e-09 0.00376303399 0 1.98830831e-05)
    list(6.24025e-09 0.00376304932 0 1.93297051e-05)
    list(6.24225e-09 0.00376306446 0 1.90788321e-05)
    list(6.24425e-09 0.00376308011 0 1.89377191e-05)
    list(6.24625e-09 0.0037630965 0 1.88402402e-05)
    list(6.24825e-09 0.00376311366 0 1.87527973e-05)
    list(6.25025e-09 0.00376313151 0 1.86570654e-05)
    list(6.25225e-09 0.00376314997 0 1.85448972e-05)
    list(6.25425e-09 0.00376316895 0 1.84173336e-05)
    list(6.25625e-09 0.00376318839 0 1.82824323e-05)
    list(6.25825e-09 0.00376320823 0 1.81507069e-05)
    list(6.26025e-09 0.00376322841 0 1.80308064e-05)
    list(6.26225e-09 0.00376324891 0 1.79275835e-05)
    list(6.26425e-09 0.00376326971 0 1.78423313e-05)
    list(6.26625e-09 0.00376329078 0 1.7773962e-05)
    list(6.26825e-09 0.00376331211 0 1.77201997e-05)
    list(6.27025e-09 0.00376333369 0 1.76784252e-05)
    list(6.27225e-09 0.0037633555 0 1.76461541e-05)
    list(6.27425e-09 0.00376337752 0 1.76212473e-05)
    list(6.27625e-09 0.00376339974 0 1.76019657e-05)
    list(6.27825e-09 0.00376342215 0 1.75869443e-05)
    list(6.28025e-09 0.00376344474 0 1.75751368e-05)
    list(6.28225e-09 0.0037634675 0 1.75657525e-05)
    list(6.28425e-09 0.00376349042 0 1.75581996e-05)
    list(6.28625e-09 0.0037635135 0 1.75520373e-05)
    list(6.28825e-09 0.00376353673 0 1.75469381e-05)
    list(6.29025e-09 0.00376356011 0 1.75426585e-05)
    list(6.29225e-09 0.00376358363 0 1.7539017e-05)
    list(6.29425e-09 0.0037636073 0 1.7535878e-05)
    list(6.29625e-09 0.0037636311 0 1.75331395e-05)
    list(6.29825e-09 0.00376365504 0 1.75307242e-05)
    list(6.3e-09 0.00376367609 0 1.75281453e-05)
    list(6.30075e-09 0.0038617743 0.15 6.56524091e-06)
    list(6.30275e-09 0.00415888305 0.55 -5.83810099e-06)
    list(6.30475e-09 0.00472889744 0.95 1.89494978e-05)
    list(6.30535e-09 0.00485356497 1 2.76212726e-05)
    list(6.30725e-09 0.00490124178 1 1.23192863e-05)
    list(6.30925e-09 0.00487539627 1 1.01351196e-05)
    list(6.31125e-09 0.00484374844 1 9.60372395e-06)
    list(6.31325e-09 0.00481186319 1 9.22694266e-06)
    list(6.31525e-09 0.00478015452 1 8.87747403e-06)
    list(6.31725e-09 0.00474865226 1 8.53860598e-06)
    list(6.31925e-09 0.00471735742 1 8.20221552e-06)
    list(6.32125e-09 0.00468626886 1 7.8570602e-06)
    list(6.32325e-09 0.00465538536 1 7.48108398e-06)
    list(6.32525e-09 0.00462470573 1 7.02934687e-06)
    list(6.32725e-09 0.00459422888 1 6.44058174e-06)
    list(6.32925e-09 0.00456395386 1 5.70877351e-06)
    list(6.33015e-09 0.00451390615 0.97 2.60905822e-05)
    list(6.33175e-09 0.00399212999 0.65 8.0188061e-06)
    list(6.33375e-09 0.00351632255 0.25 5.4670474e-05)
    list(6.33505e-09 0.00334353172 0 4.68685438e-05)
    list(6.33625e-09 0.00334352902 0 2.38267391e-05)
    list(6.33825e-09 0.00334354495 0 1.98765315e-05)
    list(6.34025e-09 0.00334356067 0 1.93244731e-05)
    list(6.34225e-09 0.00334357618 0 1.9074447e-05)
    list(6.34425e-09 0.0033435922 0 1.89339657e-05)
    list(6.34625e-09 0.00334360898 0 1.88369595e-05)
    list(6.34825e-09 0.00334362651 0 1.87498619e-05)
    list(6.35025e-09 0.00334364473 0 1.86543788e-05)
    list(6.35225e-09 0.00334366357 0 1.85424061e-05)
    list(6.35425e-09 0.00334368294 0 1.84150316e-05)
    list(6.35625e-09 0.00334370275 0 1.82803431e-05)
    list(6.35825e-09 0.00334372297 0 1.81488575e-05)
    list(6.36025e-09 0.00334374353 0 1.80292088e-05)
    list(6.36225e-09 0.00334376441 0 1.79262303e-05)
    list(6.36425e-09 0.00334378559 0 1.78412013e-05)
    list(6.36625e-09 0.00334380705 0 1.77730267e-05)
    list(6.36825e-09 0.00334382877 0 1.77194289e-05)
    list(6.37025e-09 0.00334385073 0 1.76777908e-05)
    list(6.37225e-09 0.00334387292 0 1.76456311e-05)
    list(6.37425e-09 0.00334389533 0 1.7620815e-05)
    list(6.37625e-09 0.00334391795 0 1.76016066e-05)
    list(6.37825e-09 0.00334394075 0 1.75866444e-05)
    list(6.38025e-09 0.00334396373 0 1.75748846e-05)
    list(6.38225e-09 0.00334398688 0 1.75655389e-05)
    list(6.38425e-09 0.0033440102 0 1.75580171e-05)
    list(6.38625e-09 0.00334403367 0 1.75518799e-05)
    list(6.38825e-09 0.0033440573 0 1.75468008e-05)
    list(6.39025e-09 0.00334408108 0 1.75425373e-05)
    list(6.39225e-09 0.003344105 0 1.75389088e-05)
    list(6.39425e-09 0.00334412906 0 1.753578e-05)
    list(6.39625e-09 0.00334415327 0 1.75330496e-05)
    list(6.39825e-09 0.00334417761 0 1.75306405e-05)
    list(6.4e-09 0.00334419901 0 1.75280672e-05)
    list(6.40075e-09 0.00344233392 0.15 6.56378462e-06)
    list(6.40275e-09 0.00374040067 0.55 -5.82801383e-06)
    list(6.40475e-09 0.0043131983 0.95 1.89146114e-05)
    list(6.40535e-09 0.0044386984 1 2.76237942e-05)
    list(6.40725e-09 0.00448918794 1 1.22855662e-05)
    list(6.40925e-09 0.00446608655 1 1.0096288e-05)
    list(6.41125e-09 0.0044371311 1 9.56831529e-06)
    list(6.41325e-09 0.0044079189 1 9.19506817e-06)
    list(6.41525e-09 0.00437886585 1 8.84877951e-06)
    list(6.41725e-09 0.00435000197 1 8.51275048e-06)
    list(6.41925e-09 0.00432132839 1 8.17889507e-06)
    list(6.42125e-09 0.0042928441 1 7.83600754e-06)
    list(6.42325e-09 0.00426454798 1 7.46207033e-06)
    list(6.42525e-09 0.00423643894 1 7.0121849e-06)
    list(6.42725e-09 0.00420851601 1 6.42510308e-06)
    list(6.42925e-09 0.00418077833 1 5.69478012e-06)
    list(6.43015e-09 0.00413185322 0.97 2.62865038e-05)
    list(6.43175e-09 0.00361169793 0.65 8.20221803e-06)
    list(6.43375e-09 0.00313653474 0.25 5.48346347e-05)
    list(6.43505e-09 0.00296369565 0 4.68444997e-05)
    list(6.43625e-09 0.00296369314 0 2.38146534e-05)
    list(6.43825e-09 0.00296370943 0 1.98706041e-05)
    list(6.44025e-09 0.00296372549 0 1.93197396e-05)
    list(6.44225e-09 0.00296374135 0 1.90704797e-05)
    list(6.44425e-09 0.00296375773 0 1.89305698e-05)
    list(6.44625e-09 0.00296377484 0 1.88339909e-05)
    list(6.44825e-09 0.00296379272 0 1.87472053e-05)
    list(6.45025e-09 0.0029638113 0 1.86519471e-05)
    list(6.45225e-09 0.00296383048 0 1.85401511e-05)
    list(6.45425e-09 0.00296385019 0 1.84129476e-05)
    list(6.45625e-09 0.00296387036 0 1.82784519e-05)
    list(6.45825e-09 0.00296389092 0 1.81471837e-05)
    list(6.46025e-09 0.00296391184 0 1.8027763e-05)
    list(6.46225e-09 0.00296393307 0 1.7925006e-05)
    list(6.46425e-09 0.0029639546 0 1.7840179e-05)
    list(6.46625e-09 0.00296397641 0 1.77721805e-05)
    list(6.46825e-09 0.00296399849 0 1.77187317e-05)
    list(6.47025e-09 0.00296402081 0 1.76772169e-05)
    list(6.47225e-09 0.00296404336 0 1.76451582e-05)
    list(6.47425e-09 0.00296406613 0 1.7620424e-05)
    list(6.47625e-09 0.0029640891 0 1.76012819e-05)
    list(6.47825e-09 0.00296411226 0 1.75863733e-05)
    list(6.48025e-09 0.00296413561 0 1.75746567e-05)
    list(6.48225e-09 0.00296415912 0 1.75653458e-05)
    list(6.48425e-09 0.0029641828 0 1.75578521e-05)
    list(6.48625e-09 0.00296420664 0 1.75517376e-05)
    list(6.48825e-09 0.00296423064 0 1.75466767e-05)
    list(6.49025e-09 0.00296425478 0 1.75424279e-05)
    list(6.49225e-09 0.00296427907 0 1.7538811e-05)
    list(6.49425e-09 0.0029643035 0 1.75356915e-05)
    list(6.49625e-09 0.00296432807 0 1.75329683e-05)
    list(6.49825e-09 0.00296435278 0 1.75305649e-05)
    list(6.5e-09 0.00296437451 0 1.75279967e-05)
    list(6.50075e-09 0.00306254262 0.15 6.56246407e-06)
    list(6.50275e-09 0.00336148155 0.55 -5.81892652e-06)
    list(6.50475e-09 0.00393679872 0.95 1.88827932e-05)
    list(6.50535e-09 0.00406305294 1 2.76260585e-05)
    list(6.50725e-09 0.00411608789 1 1.22553499e-05)
    list(6.50925e-09 0.00409547922 1 1.00614091e-05)
    list(6.51125e-09 0.00406896471 1 9.53653794e-06)
    list(6.51325e-09 0.00404217561 1 9.16649116e-06)
    list(6.51525e-09 0.00401552982 1 8.82307939e-06)
    list(6.51725e-09 0.00398905757 1 8.48961641e-06)
    list(6.51925e-09 0.00396276008 1 8.15805019e-06)
    list(6.52125e-09 0.00393663644 1 7.81720864e-06)
    list(6.52325e-09 0.00391068562 1 7.44510941e-06)
    list(6.52525e-09 0.00388490665 1 6.99689187e-06)
    list(6.52725e-09 0.00385929865 1 6.41132522e-06)
    list(6.52925e-09 0.00383386086 1 5.68233781e-06)
    list(6.53015e-09 0.00378595106 0.97 2.63255928e-05)
    list(6.53175e-09 0.00326726748 0.65 8.25618886e-06)
    list(6.53375e-09 0.00279269023 0.25 5.48851878e-05)
    list(6.53505e-09 0.00261980753 0 4.6828579e-05)
    list(6.53625e-09 0.00261980522 0 2.38078351e-05)
    list(6.53825e-09 0.00261982183 0 1.9868799e-05)
    list(6.54025e-09 0.00261983821 0 1.93185302e-05)
    list(6.54225e-09 0.00261985439 0 1.90695445e-05)
    list(6.54425e-09 0.00261987109 0 1.89297889e-05)
    list(6.54625e-09 0.00261988853 0 1.88332834e-05)
    list(6.54825e-09 0.00261990672 0 1.87465093e-05)
    list(6.55025e-09 0.00261992562 0 1.8651221e-05)
    list(6.55225e-09 0.00261994512 0 1.85393834e-05)
    list(6.55425e-09 0.00261996516 0 1.84121613e-05)
    list(6.55625e-09 0.00261998564 0 1.8277691e-05)
    list(6.55825e-09 0.00262000653 0 1.81464912e-05)
    list(6.56025e-09 0.00262002776 0 1.80271666e-05)
    list(6.56225e-09 0.00262004932 0 1.79245153e-05)
    list(6.56425e-09 0.00262007118 0 1.78397899e-05)
    list(6.56625e-09 0.00262009332 0 1.77718813e-05)
    list(6.56825e-09 0.00262011572 0 1.77185076e-05)
    list(6.57025e-09 0.00262013837 0 1.76770535e-05)
    list(6.57225e-09 0.00262016125 0 1.76450427e-05)
    list(6.57425e-09 0.00262018435 0 1.76203456e-05)
    list(6.57625e-09 0.00262020765 0 1.7601232e-05)
    list(6.57825e-09 0.00262023114 0 1.75863451e-05)
    list(6.58025e-09 0.00262025482 0 1.7574645e-05)
    list(6.58225e-09 0.00262027867 0 1.75653466e-05)
    list(6.58425e-09 0.00262030268 0 1.75578622e-05)
    list(6.58625e-09 0.00262032686 0 1.75517546e-05)
    list(6.58825e-09 0.00262035119 0 1.7546699e-05)
    list(6.59025e-09 0.00262037567 0 1.75424539e-05)
    list(6.59225e-09 0.00262040029 0 1.75388397e-05)
    list(6.59425e-09 0.00262042506 0 1.75357222e-05)
    list(6.59625e-09 0.00262044997 0 1.75330002e-05)
    list(6.59825e-09 0.00262047503 0 1.75305976e-05)
    list(6.6e-09 0.00262049705 0 1.75280297e-05)
    list(6.60075e-09 0.00271869518 0.15 6.56126653e-06)
    list(6.60275e-09 0.00301842772 0.55 -5.81074604e-06)
    list(6.60475e-09 0.00359602538 0.95 1.88537988e-05)
    list(6.60535e-09 0.00372296254 1 2.76280922e-05)
    list(6.60725e-09 0.00377823138 1 1.22478166e-05)
    list(6.60925e-09 0.00375995501 1 1.00772586e-05)
    list(6.61125e-09 0.00373565385 1 9.54985207e-06)
    list(6.61325e-09 0.00371106077 1 9.17826003e-06)
    list(6.61525e-09 0.00368659653 1 8.83352013e-06)
    list(6.61725e-09 0.00366229166 1 8.49888025e-06)
    list(6.61925e-09 0.00363814745 1 8.16627082e-06)
    list(6.62125e-09 0.00361416309 1 7.82450862e-06)
    list(6.62325e-09 0.00359033764 1 7.45160607e-06)
    list(6.62525e-09 0.00356667021 1 7.00270371e-06)
    list(6.62725e-09 0.00354316001 1 6.41655679e-06)
    list(6.62925e-09 0.00351980636 1 5.68704259e-06)
    list(6.63015e-09 0.00347281355 0.97 2.6168206e-05)
    list(6.63175e-09 0.00295546675 0.65 8.14875438e-06)
    list(6.63375e-09 0.00248142222 0.25 5.47942339e-05)
    list(6.63505e-09 0.00230850014 0 4.68223363e-05)
    list(6.63625e-09 0.00230849799 0 2.38074107e-05)
    list(6.63825e-09 0.0023085149 0 1.98721307e-05)
    list(6.64025e-09 0.00230853159 0 1.93217255e-05)
    list(6.64225e-09 0.00230854806 0 1.90724034e-05)
    list(6.64425e-09 0.00230856505 0 1.89322822e-05)
    list(6.64625e-09 0.00230858278 0 1.88354062e-05)
    list(6.64825e-09 0.00230860128 0 1.87482652e-05)
    list(6.65025e-09 0.00230862046 0 1.86526238e-05)
    list(6.65225e-09 0.00230864026 0 1.85404677e-05)
    list(6.65425e-09 0.00230866059 0 1.84129868e-05)
    list(6.65625e-09 0.00230868137 0 1.82783312e-05)
    list(6.65825e-09 0.00230870255 0 1.81470141e-05)
    list(6.66025e-09 0.00230872409 0 1.80276226e-05)
    list(6.66225e-09 0.00230874594 0 1.79249347e-05)
    list(6.66425e-09 0.0023087681 0 1.78401877e-05)
    list(6.66625e-09 0.00230879053 0 1.7772263e-05)
    list(6.66825e-09 0.00230881324 0 1.77188741e-05)
    list(6.67025e-09 0.00230883619 0 1.76774038e-05)
    list(6.67225e-09 0.00230885937 0 1.76453755e-05)
    list(6.67425e-09 0.00230888277 0 1.76206602e-05)
    list(6.67625e-09 0.00230890638 0 1.76015284e-05)
    list(6.67825e-09 0.00230893018 0 1.75866237e-05)
    list(6.68025e-09 0.00230895416 0 1.75749069e-05)
    list(6.68225e-09 0.00230897831 0 1.7565593e-05)
    list(6.68425e-09 0.00230900263 0 1.75580945e-05)
    list(6.68625e-09 0.00230902712 0 1.75519743e-05)
    list(6.68825e-09 0.00230905175 0 1.75469074e-05)
    list(6.69025e-09 0.00230907654 0 1.75426526e-05)
    list(6.69225e-09 0.00230910148 0 1.75390298e-05)
    list(6.69425e-09 0.00230912656 0 1.75359049e-05)
    list(6.69625e-09 0.00230915178 0 1.75331766e-05)
    list(6.69825e-09 0.00230917715 0 1.75307686e-05)
    list(6.7e-09 0.00230919945 0 1.75281949e-05)
    list(6.70075e-09 0.00240742472 0.15 6.56018106e-06)
    list(6.70275e-09 0.00270787723 0.55 -5.79527647e-06)
    list(6.70475e-09 0.00328753997 0.95 1.88445519e-05)
    list(6.70535e-09 0.00341509586 1 2.76290936e-05)
    list(6.70725e-09 0.0034723614 1 1.22476884e-05)
    list(6.70925e-09 0.00345622598 1 1.01088109e-05)
    list(6.71125e-09 0.00343393081 1 9.57719067e-06)
    list(6.71325e-09 0.00341132756 1 9.20260954e-06)
    list(6.71525e-09 0.00338884002 1 8.85525725e-06)
    list(6.71725e-09 0.00336649896 1 8.51829448e-06)
    list(6.71925e-09 0.00334430579 1 8.18361909e-06)
    list(6.72125e-09 0.00332225976 1 7.84002337e-06)
    list(6.72325e-09 0.00330036001 1 7.46550214e-06)
    list(6.72525e-09 0.00327860573 1 7.01518544e-06)
    list(6.72725e-09 0.00325699621 1 6.42780553e-06)
    list(6.72925e-09 0.00323553086 1 5.69718403e-06)
    list(6.73015e-09 0.0031893687 0.97 2.60254507e-05)
    list(6.73175e-09 0.0026732335 0.65 8.05128901e-06)
    list(6.73375e-09 0.00219967284 0.25 5.47116568e-05)
    list(6.73505e-09 0.00202671518 0 4.68166784e-05)
    list(6.73625e-09 0.00202671319 0 2.38070387e-05)
    list(6.73825e-09 0.00202673038 0 1.98751559e-05)
    list(6.74025e-09 0.00202674733 0 1.9324626e-05)
    list(6.74225e-09 0.00202676408 0 1.90749985e-05)
    list(6.74425e-09 0.00202678134 0 1.89345454e-05)
    list(6.74625e-09 0.00202679934 0 1.88373332e-05)
    list(6.74825e-09 0.0020268181 0 1.87498592e-05)
    list(6.75025e-09 0.00202683756 0 1.86538976e-05)
    list(6.75225e-09 0.00202685763 0 1.85414526e-05)
    list(6.75425e-09 0.00202687822 0 1.84137372e-05)
    list(6.75625e-09 0.00202689928 0 1.82789135e-05)
    list(6.75825e-09 0.00202692073 0 1.81474902e-05)
    list(6.76025e-09 0.00202694253 0 1.80280379e-05)
    list(6.76225e-09 0.00202696466 0 1.79253167e-05)
    list(6.76425e-09 0.00202698709 0 1.784055e-05)
    list(6.76625e-09 0.0020270098 0 1.77726106e-05)
    list(6.76825e-09 0.00202703278 0 1.77192076e-05)
    list(6.77025e-09 0.002027056 0 1.76777225e-05)
    list(6.77225e-09 0.00202707946 0 1.76456782e-05)
    list(6.77425e-09 0.00202710314 0 1.76209464e-05)
    list(6.77625e-09 0.00202712703 0 1.76017979e-05)
    list(6.77825e-09 0.0020271511 0 1.75868771e-05)
    list(6.78025e-09 0.00202717537 0 1.7575145e-05)
    list(6.78225e-09 0.0020271998 0 1.75658169e-05)
    list(6.78425e-09 0.0020272244 0 1.75583057e-05)
    list(6.78625e-09 0.00202724917 0 1.75521739e-05)
    list(6.78825e-09 0.00202727409 0 1.75470969e-05)
    list(6.79025e-09 0.00202729916 0 1.75428331e-05)
    list(6.79225e-09 0.00202732438 0 1.75392026e-05)
    list(6.79425e-09 0.00202734975 0 1.75360709e-05)
    list(6.79625e-09 0.00202737526 0 1.75333368e-05)
    list(6.79825e-09 0.00202740091 0 1.75309238e-05)
    list(6.8e-09 0.00202742345 0 1.75283448e-05)
    list(6.80075e-09 0.00212567328 0.15 6.55919849e-06)
    list(6.80275e-09 0.00242677986 0.55 -5.78020096e-06)
    list(6.80475e-09 0.00300831157 0.95 1.88383892e-05)
    list(6.80535e-09 0.00313642769 1 2.76298747e-05)
    list(6.80725e-09 0.00319550175 1 1.22474715e-05)
    list(6.80925e-09 0.00318130602 1 1.01372941e-05)
    list(6.81125e-09 0.00316082823 1 9.60186892e-06)
    list(6.81325e-09 0.00314002768 1 9.22459232e-06)
    list(6.81525e-09 0.00311933092 1 8.87488413e-06)
    list(6.81725e-09 0.00309876896 1 8.53582622e-06)
    list(6.81925e-09 0.00307834327 1 8.19928715e-06)
    list(6.82125e-09 0.0030580532 1 7.85403721e-06)
    list(6.82325e-09 0.00303789794 1 7.47805545e-06)
    list(6.82525e-09 0.00301787678 1 7.02646255e-06)
    list(6.82725e-09 0.00299798905 1 6.43797008e-06)
    list(6.82925e-09 0.00297823425 1 5.70634924e-06)
    list(6.83015e-09 0.00293282457 0.97 2.58962263e-05)
    list(6.83175e-09 0.00241778724 0.65 7.96308126e-06)
    list(6.83375e-09 0.0019446659 0.25 5.46368794e-05)
    list(6.83505e-09 0.00177167608 0 4.6811542e-05)
    list(6.83625e-09 0.00177167424 0 2.38067047e-05)
    list(6.83825e-09 0.00177169168 0 1.98778952e-05)
    list(6.84025e-09 0.00177170888 0 1.9327252e-05)
    list(6.84225e-09 0.00177172587 0 1.90773479e-05)
    list(6.84425e-09 0.00177174338 0 1.89365943e-05)
    list(6.84625e-09 0.00177176163 0 1.88390775e-05)
    list(6.84825e-09 0.00177178064 0 1.8751302e-05)
    list(6.85025e-09 0.00177180034 0 1.86550503e-05)
    list(6.85225e-09 0.00177182066 0 1.85423439e-05)
    list(6.85425e-09 0.0017718415 0 1.84144161e-05)
    list(6.85625e-09 0.0017718628 0 1.82794405e-05)
    list(6.85825e-09 0.0017718845 0 1.81479212e-05)
    list(6.86025e-09 0.00177190656 0 1.80284139e-05)
    list(6.86225e-09 0.00177192893 0 1.79256626e-05)
    list(6.86425e-09 0.00177195161 0 1.78408781e-05)
    list(6.86625e-09 0.00177197458 0 1.77729254e-05)
    list(6.86825e-09 0.0017719978 0 1.77195098e-05)
    list(6.87025e-09 0.00177202128 0 1.76780112e-05)
    list(6.87225e-09 0.001772045 0 1.76459525e-05)
    list(6.87425e-09 0.00177206893 0 1.76212056e-05)
    list(6.87625e-09 0.00177209307 0 1.76020421e-05)
    list(6.87825e-09 0.0017721174 0 1.75871067e-05)
    list(6.88025e-09 0.00177214192 0 1.75753607e-05)
    list(6.88225e-09 0.00177216661 0 1.75660199e-05)
    list(6.88425e-09 0.00177219147 0 1.7558497e-05)
    list(6.88625e-09 0.00177221649 0 1.75523548e-05)
    list(6.88825e-09 0.00177224167 0 1.75472686e-05)
    list(6.89025e-09 0.001772267 0 1.75429966e-05)
    list(6.89225e-09 0.00177229248 0 1.75393591e-05)
    list(6.89425e-09 0.00177231811 0 1.75362213e-05)
    list(6.89625e-09 0.00177234388 0 1.7533482e-05)
    list(6.89825e-09 0.00177236979 0 1.75310645e-05)
    list(6.9e-09 0.00177239257 0 1.75284807e-05)
    list(6.90075e-09 0.0018706646 0.15 6.5583097e-06)
    list(6.90275e-09 0.00217236531 0.55 -5.76655497e-06)
    list(6.90475e-09 0.00275558823 0.95 1.88327563e-05)
    list(6.90535e-09 0.00288421151 1 2.76305684e-05)
    list(6.90725e-09 0.00294492339 1 1.22472749e-05)
    list(6.90925e-09 0.00293248468 1 1.01630818e-05)
    list(6.91125e-09 0.00291365309 1 9.62420997e-06)
    list(6.91325e-09 0.00289448543 1 9.2444931e-06)
    list(6.91525e-09 0.00287541074 1 8.89265212e-06)
    list(6.91725e-09 0.00285646023 1 8.55169748e-06)
    list(6.91925e-09 0.00283763548 1 8.21347124e-06)
    list(6.92125e-09 0.00281893588 1 7.86672377e-06)
    list(6.92325e-09 0.00280036071 1 7.48941984e-06)
    list(6.92525e-09 0.00278190929 1 7.03667171e-06)
    list(6.92725e-09 0.00276358105 1 6.4471722e-06)
    list(6.92925e-09 0.00274537552 1 5.71464678e-06)
    list(6.93015e-09 0.0027006475 0.97 2.57790237e-05)
    list(6.93175e-09 0.00218660519 0.65 7.88329493e-06)
    list(6.93375e-09 0.00171388258 0.25 5.45692042e-05)
    list(6.93505e-09 0.00154086369 0 4.68068791e-05)
    list(6.93625e-09 0.00154086198 0 2.38064031e-05)
    list(6.93825e-09 0.00154087965 0 1.98803739e-05)
    list(6.94025e-09 0.00154089708 0 1.93296282e-05)
    list(6.94225e-09 0.0015409143 0 1.90794737e-05)
    list(6.94425e-09 0.00154093204 0 1.89384481e-05)
    list(6.94625e-09 0.00154095051 0 1.88406557e-05)
    list(6.94825e-09 0.00154096975 0 1.87526071e-05)
    list(6.95025e-09 0.00154098968 0 1.86560929e-05)
    list(6.95225e-09 0.00154101022 0 1.85431498e-05)
    list(6.95425e-09 0.00154103129 0 1.841503e-05)
    list(6.95625e-09 0.00154105282 0 1.8279917e-05)
    list(6.95825e-09 0.00154107474 0 1.81483109e-05)
    list(6.96025e-09 0.00154109702 0 1.8028754e-05)
    list(6.96225e-09 0.00154111963 0 1.79259756e-05)
    list(6.96425e-09 0.00154114253 0 1.7841175e-05)
    list(6.96625e-09 0.00154116573 0 1.77732104e-05)
    list(6.96825e-09 0.00154118919 0 1.77197834e-05)
    list(6.97025e-09 0.00154121289 0 1.76782725e-05)
    list(6.97225e-09 0.00154123684 0 1.76462008e-05)
    list(6.97425e-09 0.001541261 0 1.76214403e-05)
    list(6.97625e-09 0.00154128538 0 1.76022632e-05)
    list(6.97825e-09 0.00154130994 0 1.75873145e-05)
    list(6.98025e-09 0.00154133469 0 1.75755561e-05)
    list(6.98225e-09 0.00154135962 0 1.75662037e-05)
    list(6.98425e-09 0.00154138472 0 1.75586702e-05)
    list(6.98625e-09 0.00154140997 0 1.75525187e-05)
    list(6.98825e-09 0.00154143539 0 1.7547424e-05)
    list(6.99025e-09 0.00154146096 0 1.75431448e-05)
    list(6.99225e-09 0.00154148667 0 1.75395008e-05)
    list(6.99425e-09 0.00154151254 0 1.75363575e-05)
    list(6.99625e-09 0.00154153855 0 1.75336135e-05)
    list(6.99825e-09 0.0015415647 0 1.7531192e-05)
    list(7e-09 0.00154158769 0 1.75286038e-05)
    list(7.00075e-09 0.00163987979 0.15 6.55750632e-06)
    list(7.00275e-09 0.00194211997 0.55 -5.75420246e-06)
    list(7.00475e-09 0.00252687316 0.95 1.88276137e-05)
    list(7.00535e-09 0.0026559555 1 2.7631185e-05)
    list(7.00725e-09 0.00271815039 1 1.22470967e-05)
    list(7.00925e-09 0.00270730298 1 1.01864266e-05)
    list(7.01125e-09 0.00268996229 1 9.64443305e-06)
    list(7.01325e-09 0.00267227347 1 9.26250717e-06)
    list(7.01525e-09 0.00265466778 1 8.90873559e-06)
    list(7.01725e-09 0.00263717668 1 8.56606404e-06)
    list(7.01925e-09 0.00261980178 1 8.22631057e-06)
    list(7.02125e-09 0.00260254254 1 7.87820755e-06)
    list(7.02325e-09 0.0025853983 1 7.49970683e-06)
    list(7.02525e-09 0.00256836844 1 7.04591306e-06)
    list(7.02725e-09 0.00255145245 1 6.4555021e-06)
    list(7.02925e-09 0.00253464994 1 5.72215796e-06)
    list(7.03015e-09 0.00249053806 0.97 2.56734283e-05)
    list(7.03175e-09 0.00197739695 0.65 7.81109382e-06)
    list(7.03375e-09 0.00150503613 0.25 5.45080186e-05)
    list(7.03505e-09 0.00133199096 0 4.68026822e-05)
    list(7.03625e-09 0.00133198936 0 2.38061471e-05)
    list(7.03825e-09 0.00133200725 0 1.98826309e-05)
    list(7.04025e-09 0.00133202488 0 1.93317911e-05)
    list(7.04225e-09 0.00133204231 0 1.90814092e-05)
    list(7.04425e-09 0.00133206025 0 1.89401368e-05)
    list(7.04625e-09 0.00133207893 0 1.88420943e-05)
    list(7.04825e-09 0.00133209837 0 1.87537982e-05)
    list(7.05025e-09 0.00133211851 0 1.86570459e-05)
    list(7.05225e-09 0.00133213926 0 1.85438882e-05)
    list(7.05425e-09 0.00133216053 0 1.84155942e-05)
    list(7.05625e-09 0.00133218227 0 1.82803566e-05)
    list(7.05825e-09 0.0013322044 0 1.81486716e-05)
    list(7.06025e-09 0.00133222689 0 1.80290694e-05)
    list(7.06225e-09 0.0013322497 0 1.79262661e-05)
    list(7.06425e-09 0.00133227282 0 1.78414506e-05)
    list(7.06625e-09 0.00133229622 0 1.77734747e-05)
    list(7.06825e-09 0.00133231989 0 1.77200369e-05)
    list(7.07025e-09 0.00133234381 0 1.76785147e-05)
    list(7.07225e-09 0.00133236796 0 1.76464307e-05)
    list(7.07425e-09 0.00133239234 0 1.76216576e-05)
    list(7.07625e-09 0.00133241692 0 1.76024677e-05)
    list(7.07825e-09 0.0013324417 0 1.75875067e-05)
    list(7.08025e-09 0.00133246667 0 1.75757366e-05)
    list(7.08225e-09 0.00133249181 0 1.75663734e-05)
    list(7.08425e-09 0.00133251712 0 1.75588302e-05)
    list(7.08625e-09 0.00133254259 0 1.75526698e-05)
    list(7.08825e-09 0.00133256822 0 1.75475673e-05)
    list(7.09025e-09 0.00133259401 0 1.75432812e-05)
    list(7.09225e-09 0.00133261994 0 1.75396313e-05)
    list(7.09425e-09 0.00133264602 0 1.75364827e-05)
    list(7.09625e-09 0.00133267225 0 1.75337342e-05)
    list(7.09825e-09 0.00133269862 0 1.75313088e-05)
    list(7.1e-09 0.0013327218 1.65436123e-13 1.75287165e-05)
    list(7.10075e-09 0.00143103206 0.15 6.55678054e-06)
    list(7.10275e-09 0.00173376186 0.55 -5.74302127e-06)
    list(7.10475e-09 0.00231989963 0.95 1.88229234e-05)
    list(7.10535e-09 0.00244939747 1 2.76317332e-05)
    list(7.10725e-09 0.00251293504 1 1.22469351e-05)
    list(7.10925e-09 0.00250353276 1 1.0207594e-05)
    list(7.11125e-09 0.00248754241 1 9.66271347e-06)
    list(7.11325e-09 0.00247119269 1 9.27878713e-06)
    list(7.11525e-09 0.0024549172 1 8.92327115e-06)
    list(7.11725e-09 0.00243874757 1 8.57904851e-06)
    list(7.11925e-09 0.00242268549 1 8.23791528e-06)
    list(7.12125e-09 0.00240673046 1 7.88858753e-06)
    list(7.12325e-09 0.00239088189 1 7.5090055e-06)
    list(7.12525e-09 0.0023751392 1 7.054267e-06)
    list(7.12725e-09 0.00235950195 1 6.46303256e-06)
    list(7.12925e-09 0.00234396977 1 5.72894868e-06)
    list(7.13015e-09 0.00230041577 0.97 2.55776566e-05)
    list(7.13175e-09 0.00178809125 0.65 7.74580863e-06)
    list(7.13375e-09 0.00131605858 0.25 5.44526804e-05)
    list(7.13505e-09 0.00114298963 0 4.6798879e-05)
    list(7.13625e-09 0.00114298815 0 2.38059174e-05)
    list(7.13825e-09 0.00114300623 0 1.9884674e-05)
    list(7.14025e-09 0.00114302406 0 1.9333749e-05)
    list(7.14225e-09 0.00114304167 0 1.90831613e-05)
    list(7.14425e-09 0.0011430598 0 1.89416655e-05)
    list(7.14625e-09 0.00114307867 0 1.88433968e-05)
    list(7.14825e-09 0.0011430983 0 1.87548766e-05)
    list(7.15025e-09 0.00114311862 0 1.86579087e-05)
    list(7.15225e-09 0.00114313956 0 1.85445568e-05)
    list(7.15425e-09 0.00114316102 0 1.84161053e-05)
    list(7.15625e-09 0.00114318294 0 1.8280755e-05)
    list(7.15825e-09 0.00114320526 0 1.81489987e-05)
    list(7.16025e-09 0.00114322794 0 1.80293556e-05)
    list(7.16225e-09 0.00114325094 0 1.79265297e-05)
    list(7.16425e-09 0.00114327425 0 1.78417007e-05)
    list(7.16625e-09 0.00114329784 0 1.77737146e-05)
    list(7.16825e-09 0.0011433217 0 1.77202671e-05)
    list(7.17025e-09 0.00114334582 0 1.76787345e-05)
    list(7.17225e-09 0.00114337016 0 1.76466394e-05)
    list(7.17425e-09 0.00114339473 0 1.76218548e-05)
    list(7.17625e-09 0.00114341951 0 1.76026534e-05)
    list(7.17825e-09 0.00114344449 0 1.75876812e-05)
    list(7.18025e-09 0.00114346965 0 1.75759005e-05)
    list(7.18225e-09 0.00114349498 0 1.75665275e-05)
    list(7.18425e-09 0.00114352049 0 1.75589754e-05)
    list(7.18625e-09 0.00114354616 0 1.7552807e-05)
    list(7.18825e-09 0.00114357198 0 1.75476974e-05)
    list(7.19025e-09 0.00114359796 0 1.7543405e-05)
    list(7.19225e-09 0.0011436241 0 1.75397496e-05)
    list(7.19425e-09 0.00114365037 0 1.75365963e-05)
    list(7.19625e-09 0.0011436768 0 1.75338437e-05)
    list(7.19825e-09 0.00114370337 0 1.75314148e-05)
    list(7.2e-09 0.00114372672 0 1.75288187e-05)
    list(7.20075e-09 0.0012420534 0.15 6.55612547e-06)
    list(7.20275e-09 0.00154522742 0.55 -5.73289947e-06)
    list(7.20475e-09 0.00213261787 0.95 1.88186497e-05)
    list(7.20535e-09 0.00226249174 1 2.76322209e-05)
    list(7.20725e-09 0.00232724066 1 1.22467058e-05)
    list(7.20925e-09 0.00231914668 1 1.02266279e-05)
    list(7.21125e-09 0.00230437895 1 9.67918464e-06)
    list(7.21325e-09 0.00228924173 1 9.29344814e-06)
    list(7.21525e-09 0.00227417064 1 8.93635118e-06)
    list(7.21725e-09 0.0022591975 1 8.5907234e-06)
    list(7.21925e-09 0.00224432406 1 8.24834102e-06)
    list(7.22125e-09 0.00222954988 1 7.89790522e-06)
    list(7.22325e-09 0.00221487439 1 7.51734557e-06)
    list(7.22525e-09 0.00220029709 1 7.06175359e-06)
    list(7.22725e-09 0.00218581755 1 6.4697758e-06)
    list(7.22925e-09 0.0021714355 1 5.7350246e-06)
    list(7.23015e-09 0.00212838668 0.97 2.54909903e-05)
    list(7.23175e-09 0.0016168016 0.65 7.68674029e-06)
    list(7.23375e-09 0.00114506645 0.25 5.44025927e-05)
    list(7.23505e-09 0.000971976023 0 4.67954306e-05)
    list(7.23625e-09 0.000971974639 0 2.38057107e-05)
    list(7.23825e-09 0.000971992891 0 1.98865232e-05)
    list(7.24025e-09 0.000972010892 0 1.93355208e-05)
    list(7.24225e-09 0.000972028681 0 1.90847469e-05)
    list(7.24425e-09 0.00097204698 0 1.89430489e-05)
    list(7.24625e-09 0.000972066021 0 1.88445754e-05)
    list(7.24825e-09 0.00097208582 0 1.87558523e-05)
    list(7.25025e-09 0.000972106315 0 1.86586894e-05)
    list(7.25225e-09 0.000972127422 0 1.85451618e-05)
    list(7.25425e-09 0.000972149058 0 1.84165678e-05)
    list(7.25625e-09 0.000972171151 0 1.82811155e-05)
    list(7.25825e-09 0.000972193643 0 1.81492947e-05)
    list(7.26025e-09 0.000972216492 0 1.80296147e-05)
    list(7.26225e-09 0.000972239668 0 1.79267684e-05)
    list(7.26425e-09 0.000972263149 0 1.78419272e-05)
    list(7.26625e-09 0.000972286915 0 1.77739319e-05)
    list(7.26825e-09 0.00097231095 0 1.77204755e-05)
    list(7.27025e-09 0.000972335238 0 1.76789335e-05)
    list(7.27225e-09 0.000972359762 0 1.76468284e-05)
    list(7.27425e-09 0.000972384508 0 1.76220333e-05)
    list(7.27625e-09 0.000972409462 0 1.76028215e-05)
    list(7.27825e-09 0.000972434613 0 1.75878392e-05)
    list(7.28025e-09 0.00097245995 0 1.75760489e-05)
    list(7.28225e-09 0.000972485464 0 1.75666671e-05)
    list(7.28425e-09 0.000972511147 0 1.75591068e-05)
    list(7.28625e-09 0.000972536995 0 1.75529312e-05)
    list(7.28825e-09 0.000972563001 0 1.75478152e-05)
    list(7.29025e-09 0.000972589161 0 1.75435171e-05)
    list(7.29225e-09 0.000972615472 0 1.75398568e-05)
    list(7.29425e-09 0.000972641931 0 1.75366992e-05)
    list(7.29625e-09 0.000972668537 0 1.75339429e-05)
    list(7.29825e-09 0.000972695286 0 1.75315108e-05)
    list(7.3e-09 0.000972718798 0 1.75289113e-05)
    list(7.30075e-09 0.00107106032 0.15 6.55553466e-06)
    list(7.30275e-09 0.00137463726 0.55 -5.72373631e-06)
    list(7.30475e-09 0.00196316102 0.95 1.88147587e-05)
    list(7.30535e-09 0.00209337518 1 2.7632655e-05)
    list(7.30725e-09 0.00215921719 1 1.22464098e-05)
    list(7.30925e-09 0.00215230938 1 1.02319621e-05)
    list(7.31125e-09 0.00213864937 1 9.68327991e-06)
    list(7.31325e-09 0.00212460997 1 9.29701926e-06)
    list(7.31525e-09 0.00211062932 1 8.93949623e-06)
    list(7.31725e-09 0.00209673943 1 8.59349313e-06)
    list(7.31925e-09 0.00208294211 1 8.25077899e-06)
    list(7.32125e-09 0.00206923696 1 7.90005192e-06)
    list(7.32325e-09 0.00205562348 1 7.51924119e-06)
    list(7.32525e-09 0.0020421012 1 7.06344103e-06)
    list(7.32725e-09 0.00202866974 1 6.47129284e-06)
    list(7.32925e-09 0.00201532888 1 5.73638482e-06)
    list(7.33015e-09 0.00197273755 0.97 2.54127582e-05)
    list(7.33175e-09 0.00146182196 0.65 7.6334579e-06)
    list(7.33375e-09 0.000990356515 0.25 5.43574019e-05)
    list(7.33505e-09 0.000817246654 0 4.67922965e-05)
    list(7.33625e-09 0.000817245362 0 2.38055183e-05)
    list(7.33825e-09 0.000817263774 0 1.98881912e-05)
    list(7.34025e-09 0.000817281932 0 1.93371193e-05)
    list(7.34225e-09 0.000817299878 0 1.90861773e-05)
    list(7.34425e-09 0.000817318333 0 1.89442968e-05)
    list(7.34625e-09 0.000817337529 0 1.88456383e-05)
    list(7.34825e-09 0.000817357484 0 1.8756732e-05)
    list(7.35025e-09 0.000817378135 0 1.86593929e-05)
    list(7.35225e-09 0.000817399398 0 1.85457066e-05)
    list(7.35425e-09 0.00081742119 0 1.84169839e-05)
    list(7.35625e-09 0.000817443439 0 1.82814396e-05)
    list(7.35825e-09 0.000817466087 0 1.81495607e-05)
    list(7.36025e-09 0.000817489093 0 1.80298475e-05)
    list(7.36225e-09 0.000817512426 0 1.7926983e-05)
    list(7.36425e-09 0.000817536065 0 1.78421309e-05)
    list(7.36625e-09 0.000817559989 0 1.77741274e-05)
    list(7.36825e-09 0.000817584183 0 1.77206632e-05)
    list(7.37025e-09 0.00081760863 0 1.76791128e-05)
    list(7.37225e-09 0.000817633313 0 1.76469987e-05)
    list(7.37425e-09 0.000817658219 0 1.76221943e-05)
    list(7.37625e-09 0.000817683334 0 1.76029731e-05)
    list(7.37825e-09 0.000817708646 0 1.75879817e-05)
    list(7.38025e-09 0.000817734144 0 1.75761828e-05)
    list(7.38225e-09 0.00081775982 0 1.7566793e-05)
    list(7.38425e-09 0.000817785666 0 1.75592255e-05)
    list(7.38625e-09 0.000817811675 0 1.75530433e-05)
    list(7.38825e-09 0.000817837844 0 1.75479215e-05)
    list(7.39025e-09 0.000817864168 0 1.75436184e-05)
    list(7.39225e-09 0.000817890642 0 1.75399536e-05)
    list(7.39425e-09 0.000817917266 0 1.75367921e-05)
    list(7.39625e-09 0.000817944035 0 1.75340325e-05)
    list(7.39825e-09 0.000817970949 0 1.75315975e-05)
    list(7.4e-09 0.000817994606 0 1.7528995e-05)
    list(7.40075e-09 0.000916349554 0.15 6.55500223e-06)
    list(7.40275e-09 0.00122029184 0.55 -5.7154406e-06)
    list(7.40475e-09 0.00180984015 0.95 1.88111599e-05)
    list(7.40535e-09 0.00194036302 1 2.76330419e-05)
    list(7.40725e-09 0.00200719476 1 1.22461426e-05)
    list(7.40925e-09 0.00200135892 1 1.02172142e-05)
    list(7.41125e-09 0.00198870275 1 9.66920101e-06)
    list(7.41325e-09 0.00197565727 1 9.28431255e-06)
    list(7.41525e-09 0.00196266376 1 8.92806813e-06)
    list(7.41725e-09 0.00194975448 1 8.58320893e-06)
    list(7.41925e-09 0.00193693131 1 8.24151553e-06)
    list(7.42125e-09 0.00192419389 1 7.8917007e-06)
    list(7.42325e-09 0.00191154175 1 7.51170918e-06)
    list(7.42525e-09 0.00189897447 1 7.05665179e-06)
    list(7.42725e-09 0.00188649173 1 6.4651778e-06)
    list(7.42925e-09 0.00187409332 1 5.73086455e-06)
    list(7.43015e-09 0.00183191628 0.97 2.5342287e-05)
    list(7.43175e-09 0.00132160677 0.65 7.58551671e-06)
    list(7.43375e-09 0.000850385748 0.25 5.43167362e-05)
    list(7.43505e-09 0.000677258313 0 4.67894389e-05)
    list(7.43625e-09 0.000677257104 0 2.38053332e-05)
    list(7.43825e-09 0.000677275661 0 1.98896909e-05)
    list(7.44025e-09 0.000677293962 0 1.93385573e-05)
    list(7.44225e-09 0.00067731205 0 1.90874642e-05)
    list(7.44425e-09 0.000677330648 0 1.89454193e-05)
    list(7.44625e-09 0.000677349986 0 1.88465941e-05)
    list(7.44825e-09 0.000677370082 0 1.87575227e-05)
    list(7.45025e-09 0.000677390875 0 1.86600246e-05)
    list(7.45225e-09 0.000677412279 0 1.85461952e-05)
    list(7.45425e-09 0.000677434213 0 1.84173565e-05)
    list(7.45625e-09 0.000677456604 0 1.82817295e-05)
    list(7.45825e-09 0.000677479395 0 1.81497984e-05)
    list(7.46025e-09 0.000677502543 0 1.80300555e-05)
    list(7.46225e-09 0.000677526019 0 1.79271748e-05)
    list(7.46425e-09 0.000677549801 0 1.78423132e-05)
    list(7.46625e-09 0.00067757387 0 1.77743025e-05)
    list(7.46825e-09 0.000677598208 0 1.77208313e-05)
    list(7.47025e-09 0.000677622799 0 1.76792735e-05)
    list(7.47225e-09 0.000677647628 0 1.76471515e-05)
    list(7.47425e-09 0.000677672679 0 1.76223388e-05)
    list(7.47625e-09 0.00067769794 0 1.76031092e-05)
    list(7.47825e-09 0.000677723398 0 1.75881097e-05)
    list(7.48025e-09 0.000677749043 0 1.75763031e-05)
    list(7.48225e-09 0.000677774865 0 1.75669062e-05)
    list(7.48425e-09 0.000677800859 0 1.75593322e-05)
    list(7.48625e-09 0.000677827016 0 1.75531442e-05)
    list(7.48825e-09 0.000677853333 0 1.75480172e-05)
    list(7.49025e-09 0.000677879805 0 1.75437095e-05)
    list(7.49225e-09 0.000677906428 0 1.75400407e-05)
    list(7.49425e-09 0.000677933201 0 1.75368759e-05)
    list(7.49625e-09 0.00067796012 0 1.75341133e-05)
    list(7.49825e-09 0.000677987183 0 1.75316757e-05)
    list(7.5e-09 0.000678010971 0 1.75290704e-05)
    list(7.50075e-09 0.00077637806 0.15 6.55452283e-06)
    list(7.50275e-09 0.00108065103 0.55 -5.70795279e-06)
    list(7.50475e-09 0.00167112574 0.95 1.88078293e-05)
    list(7.50535e-09 0.00180192947 1 2.76333856e-05)
    list(7.50725e-09 0.00186965758 1 1.22459013e-05)
    list(7.50925e-09 0.00186479204 1 1.02038741e-05)
    list(7.51125e-09 0.00185304446 1 9.65646524e-06)
    list(7.51325e-09 0.00184089859 1 9.27281855e-06)
    list(7.51525e-09 0.00182879854 1 8.91773122e-06)
    list(7.51725e-09 0.00181677682 1 8.57390719e-06)
    list(7.51925e-09 0.00180483533 1 8.23313751e-06)
    list(7.52125e-09 0.00179297379 1 7.88414826e-06)
    list(7.52325e-09 0.00178119174 1 7.50489833e-06)
    list(7.52525e-09 0.00176948882 1 7.0505137e-06)
    list(7.52725e-09 0.00175786473 1 6.45965075e-06)
    list(7.52925e-09 0.00174631932 1 5.72587635e-06)
    list(7.53015e-09 0.00170451722 0.97 2.52785305e-05)
    list(7.53175e-09 0.00119475632 0.65 7.54214987e-06)
    list(7.53375e-09 0.000723756752 0.25 5.42799332e-05)
    list(7.53505e-09 0.00055061343 0 4.67868387e-05)
    list(7.53625e-09 0.000550612296 0 2.3805162e-05)
    list(7.53825e-09 0.000550630986 0 1.98910468e-05)
    list(7.54025e-09 0.000550649417 0 1.93398579e-05)
    list(7.54225e-09 0.000550667634 0 1.90886283e-05)
    list(7.54425e-09 0.00055068636 0 1.89464348e-05)
    list(7.54625e-09 0.000550705827 0 1.88474588e-05)
    list(7.54825e-09 0.000550726053 0 1.87582378e-05)
    list(7.55025e-09 0.000550746974 0 1.8660596e-05)
    list(7.55225e-09 0.000550768507 0 1.8546637e-05)
    list(7.55425e-09 0.000550790569 0 1.84176933e-05)
    list(7.55625e-09 0.000550813089 0 1.82819915e-05)
    list(7.55825e-09 0.000550836009 0 1.81500133e-05)
    list(7.56025e-09 0.000550859287 0 1.80302436e-05)
    list(7.56225e-09 0.000550882893 0 1.79273483e-05)
    list(7.56425e-09 0.000550906805 0 1.7842478e-05)
    list(7.56625e-09 0.000550931004 0 1.77744609e-05)
    list(7.56825e-09 0.000550955473 0 1.77209835e-05)
    list(7.57025e-09 0.000550980196 0 1.7679419e-05)
    list(7.57225e-09 0.000551005157 0 1.76472898e-05)
    list(7.57425e-09 0.00055103034 0 1.76224695e-05)
    list(7.57625e-09 0.000551055734 0 1.76032324e-05)
    list(7.57825e-09 0.000551081324 0 1.75882256e-05)
    list(7.58025e-09 0.000551107102 0 1.75764121e-05)
    list(7.58225e-09 0.000551133058 0 1.75670086e-05)
    list(7.58425e-09 0.000551159185 0 1.75594288e-05)
    list(7.58625e-09 0.000551185477 0 1.75532355e-05)
    list(7.58825e-09 0.000551211928 0 1.75481039e-05)
    list(7.59025e-09 0.000551238535 0 1.7543792e-05)
    list(7.59225e-09 0.000551265293 0 1.75401197e-05)
    list(7.59425e-09 0.000551292201 0 1.75369517e-05)
    list(7.59625e-09 0.000551319256 0 1.75341864e-05)
    list(7.59825e-09 0.000551346456 0 1.75317465e-05)
    list(7.6e-09 0.000551370363 0 1.75291387e-05)
    list(7.60075e-09 0.00064974843 0.15 6.55409156e-06)
    list(7.60275e-09 0.000954321044 0.55 -5.70117567e-06)
    list(7.60475e-09 0.00154563382 0.95 1.88048065e-05)
    list(7.60535e-09 0.00167669168 1 2.76336914e-05)
    list(7.60725e-09 0.00174523096 1 1.22456825e-05)
    list(7.60925e-09 0.00174124356 1 1.01918064e-05)
    list(7.61125e-09 0.00173031829 1 9.64494311e-06)
    list(7.61325e-09 0.00171898659 1 9.2624198e-06)
    list(7.61525e-09 0.00170769515 1 8.90837928e-06)
    list(7.61725e-09 0.00169647668 1 8.56549175e-06)
    list(7.61925e-09 0.00168533315 1 8.22555776e-06)
    list(7.62125e-09 0.00167426427 1 7.87731543e-06)
    list(7.62325e-09 0.00166326967 1 7.49873643e-06)
    list(7.62525e-09 0.001652349 1 7.04496049e-06)
    list(7.62725e-09 0.00164150199 1 6.45465043e-06)
    list(7.62925e-09 0.00163072852 1 5.72136359e-06)
    list(7.63015e-09 0.00158926575 0.97 2.52208462e-05)
    list(7.63175e-09 0.0010800014 0.65 7.50291805e-06)
    list(7.63375e-09 0.000609202439 0.25 5.42466299e-05)
    list(7.63505e-09 0.000436044754 0 4.67844826e-05)
    list(7.63625e-09 0.000436043689 0 2.38050073e-05)
    list(7.63825e-09 0.000436062498 0 1.98922734e-05)
    list(7.64025e-09 0.000436081047 0 1.93410345e-05)
    list(7.64225e-09 0.000436099382 0 1.90896814e-05)
    list(7.64425e-09 0.000436118226 0 1.89473535e-05)
    list(7.64625e-09 0.00043613781 0 1.8848241e-05)
    list(7.64825e-09 0.000436158152 0 1.87588848e-05)
    list(7.65025e-09 0.00043617919 0 1.86611128e-05)
    list(7.65225e-09 0.000436200839 0 1.85470366e-05)
    list(7.65425e-09 0.000436223019 0 1.8417998e-05)
    list(7.65625e-09 0.000436245655 0 1.82822285e-05)
    list(7.65825e-09 0.000436268692 0 1.81502077e-05)
    list(7.66025e-09 0.000436292088 0 1.80304138e-05)
    list(7.66225e-09 0.000436315812 0 1.79275053e-05)
    list(7.66425e-09 0.000436339842 0 1.78426272e-05)
    list(7.66625e-09 0.00043636416 0 1.77746042e-05)
    list(7.66825e-09 0.000436388748 0 1.77211212e-05)
    list(7.67025e-09 0.00043641359 0 1.76795507e-05)
    list(7.67225e-09 0.00043643867 0 1.76474149e-05)
    list(7.67425e-09 0.000436463974 0 1.76225879e-05)
    list(7.67625e-09 0.000436489487 0 1.76033439e-05)
    list(7.67825e-09 0.000436515199 0 1.75883304e-05)
    list(7.68025e-09 0.000436541097 0 1.75765106e-05)
    list(7.68225e-09 0.000436567175 0 1.75671014e-05)
    list(7.68425e-09 0.000436593423 0 1.75595162e-05)
    list(7.68625e-09 0.000436619836 0 1.75533182e-05)
    list(7.68825e-09 0.00043664641 0 1.75481823e-05)
    list(7.69025e-09 0.000436673139 0 1.75438667e-05)
    list(7.69225e-09 0.00043670002 0 1.75401911e-05)
    list(7.69425e-09 0.00043672705 0 1.75370203e-05)
    list(7.69625e-09 0.000436754228 0 1.75342525e-05)
    list(7.69825e-09 0.000436781551 0 1.75318106e-05)
    list(7.7e-09 0.000436805567 0 1.75292005e-05)
    list(7.70075e-09 0.000535193561 0.15 6.55370396e-06)
    list(7.70275e-09 0.000840037668 0.55 -5.69503935e-06)
    list(7.70475e-09 0.00143210852 0.95 1.88020615e-05)
    list(7.70535e-09 0.00156339632 1 2.76339635e-05)
    list(7.70725e-09 0.00163266959 1 1.22454841e-05)
    list(7.70925e-09 0.00162947687 1 1.01808903e-05)
    list(7.71125e-09 0.00161929576 1 9.63451952e-06)
    list(7.71325e-09 0.00160870086 1 9.25301242e-06)
    list(7.71525e-09 0.00159814118 1 8.89991886e-06)
    list(7.71725e-09 0.00158764961 1 8.55787853e-06)
    list(7.71925e-09 0.00157722818 1 8.21870053e-06)
    list(7.72125e-09 0.00156687664 1 7.87113388e-06)
    list(7.72325e-09 0.00155659462 1 7.49316184e-06)
    list(7.72525e-09 0.00154638183 1 7.03993659e-06)
    list(7.72725e-09 0.00153623803 1 6.45012673e-06)
    list(7.72925e-09 0.00152616312 1 5.71728098e-06)
    list(7.73015e-09 0.0014850074 0.97 2.51686573e-05)
    list(7.73175e-09 0.000976192438 0.65 7.46742771e-06)
    list(7.73375e-09 0.000505575177 0.25 5.4216495e-05)
    list(7.73505e-09 0.000332404507 0 4.67823484e-05)
    list(7.73625e-09 0.000332403505 0 2.38048676e-05)
    list(7.73825e-09 0.000332422423 0 1.98933831e-05)
    list(7.74025e-09 0.000332441079 0 1.9342099e-05)
    list(7.74225e-09 0.00033245952 0 1.90906341e-05)
    list(7.74425e-09 0.000332478469 0 1.89481845e-05)
    list(7.74625e-09 0.00033249816 0 1.88489486e-05)
    list(7.74825e-09 0.000332518608 0 1.87594699e-05)
    list(7.75025e-09 0.000332539751 0 1.86615802e-05)
    list(7.75225e-09 0.000332561507 0 1.8547398e-05)
    list(7.75425e-09 0.000332583792 0 1.84182736e-05)
    list(7.75625e-09 0.000332606535 0 1.82824428e-05)
    list(7.75825e-09 0.000332629678 0 1.81503835e-05)
    list(7.76025e-09 0.00033265318 0 1.80305677e-05)
    list(7.76225e-09 0.000332677011 0 1.79276473e-05)
    list(7.76425e-09 0.000332701149 0 1.78427622e-05)
    list(7.76625e-09 0.000332725574 0 1.77747339e-05)
    list(7.76825e-09 0.00033275027 0 1.77212458e-05)
    list(7.77025e-09 0.00033277522 0 1.76796698e-05)
    list(7.77225e-09 0.000332800409 0 1.76475282e-05)
    list(7.77425e-09 0.000332825821 0 1.7622695e-05)
    list(7.77625e-09 0.000332851444 0 1.76034449e-05)
    list(7.77825e-09 0.000332877264 0 1.75884253e-05)
    list(7.78025e-09 0.000332903272 0 1.75765999e-05)
    list(7.78225e-09 0.00033292946 0 1.75671853e-05)
    list(7.78425e-09 0.000332955818 0 1.75595954e-05)
    list(7.78625e-09 0.000332982342 0 1.7553393e-05)
    list(7.78825e-09 0.000333009026 0 1.75482533e-05)
    list(7.79025e-09 0.000333035866 0 1.75439344e-05)
    list(7.79225e-09 0.000333062858 0 1.75402558e-05)
    list(7.79425e-09 0.00033309 0 1.75370824e-05)
    list(7.79625e-09 0.00033311729 0 1.75343124e-05)
    list(7.79825e-09 0.000333144724 0 1.75318686e-05)
    list(7.8e-09 0.000333168838 0 1.75292565e-05)
    list(7.80075e-09 0.000431565809 0.15 6.55335598e-06)
    list(7.80275e-09 0.000736655862 0.55 -5.68948271e-06)
    list(7.80475e-09 0.00132941242 0.95 1.87995699e-05)
    list(7.80535e-09 0.00146090824 1 2.76342057e-05)
    list(7.80725e-09 0.00153084573 1 1.22453042e-05)
    list(7.80925e-09 0.00152837214 1 1.01710161e-05)
    list(7.81125e-09 0.00151886443 1 9.62509013e-06)
    list(7.81325e-09 0.00150893625 1 9.24450225e-06)
    list(7.81525e-09 0.00149903873 1 8.8922653e-06)
    list(7.81725e-09 0.00148920494 1 8.55099133e-06)
    list(7.81925e-09 0.00147943692 1 8.21249719e-06)
    list(7.82125e-09 0.00146973448 1 7.86554178e-06)
    list(7.82325e-09 0.00146009727 1 7.48811881e-06)
    list(7.82525e-09 0.00145052502 1 7.03539171e-06)
    list(7.82725e-09 0.00144101753 1 6.44603437e-06)
    list(7.82925e-09 0.00143157473 1 5.71358767e-06)
    list(7.83015e-09 0.00139069685 0.97 2.51214417e-05)
    list(7.83175e-09 0.000882298651 0.65 7.43521606e-06)
    list(7.83375e-09 0.000411846461 0.25 5.41890403e-05)
    list(7.83505e-09 0.000238664061 0 4.67804346e-05)
    list(7.83625e-09 0.000238663115 0 2.38047526e-05)
    list(7.83825e-09 0.000238682132 0 1.98943949e-05)
    list(7.84025e-09 0.000238700885 0 1.93430685e-05)
    list(7.84225e-09 0.000238719423 0 1.90915018e-05)
    list(7.84425e-09 0.000238738469 0 1.89489414e-05)
    list(7.84625e-09 0.000238758255 0 1.88495932e-05)
    list(7.84825e-09 0.0002387788 0 1.87600033e-05)
    list(7.85025e-09 0.000238800039 0 1.86620066e-05)
    list(7.85225e-09 0.000238821891 0 1.85477281e-05)
    list(7.85425e-09 0.000238844273 0 1.84185257e-05)
    list(7.85625e-09 0.000238867112 0 1.82826393e-05)
    list(7.85825e-09 0.000238890352 0 1.81505449e-05)
    list(7.86025e-09 0.00023891395 0 1.8030709e-05)
    list(7.86225e-09 0.000238937878 0 1.79277775e-05)
    list(7.86425e-09 0.000238962113 0 1.78428859e-05)
    list(7.86625e-09 0.000238986636 0 1.77748526e-05)
    list(7.86825e-09 0.00023901143 0 1.77213598e-05)
    list(7.87025e-09 0.000239036479 0 1.76797787e-05)
    list(7.87225e-09 0.000239061766 0 1.76476316e-05)
    list(7.87425e-09 0.000239087277 0 1.76227927e-05)
    list(7.87625e-09 0.000239112998 0 1.76035369e-05)
    list(7.87825e-09 0.000239138918 0 1.75885119e-05)
    list(7.88025e-09 0.000239165026 0 1.75766812e-05)
    list(7.88225e-09 0.000239191313 0 1.75672618e-05)
    list(7.88425e-09 0.000239217772 0 1.75596674e-05)
    list(7.88625e-09 0.000239244396 0 1.75534611e-05)
    list(7.88825e-09 0.00023927118 0 1.75483179e-05)
    list(7.89025e-09 0.000239298121 0 1.75439959e-05)
    list(7.89225e-09 0.000239325214 0 1.75403146e-05)
    list(7.89425e-09 0.000239352457 0 1.75371389e-05)
    list(7.89625e-09 0.000239379848 0 1.75343669e-05)
    list(7.89825e-09 0.000239407385 0 1.75319213e-05)
    list(7.9e-09 0.000239431587 0 1.75293073e-05)
    list(7.90075e-09 0.000337836676 0.15 6.55304469e-06)
    list(7.90275e-09 0.00064314954 0.55 -5.68443828e-06)
    list(7.90475e-09 0.00123652633 0.95 1.87973055e-05)
    list(7.90535e-09 0.00136821033 1 2.76344229e-05)
    list(7.90725e-09 0.00143874863 1 1.22451415e-05)
    list(7.90925e-09 0.00143692564 1 1.01620861e-05)
    list(7.91125e-09 0.00142802717 1 9.61656173e-06)
    list(7.91325e-09 0.00141870221 1 9.23680517e-06)
    list(7.91525e-09 0.00140940377 1 8.88534295e-06)
    list(7.91725e-09 0.00140016508 1 8.54476208e-06)
    list(7.91925e-09 0.00139098823 1 8.20688644e-06)
    list(7.92125e-09 0.00138187304 1 7.86048384e-06)
    list(7.92325e-09 0.00137281921 1 7.48355748e-06)
    list(7.92525e-09 0.00136382646 1 7.03128095e-06)
    list(7.92725e-09 0.00135489465 1 6.44233289e-06)
    list(7.92925e-09 0.00134602372 1 5.71024713e-06)
    list(7.93015e-09 0.00130539721 0.97 2.50787311e-05)
    list(7.93175e-09 0.000797366981 0.65 7.40617684e-06)
    list(7.93375e-09 0.000327063762 0.25 5.4164372e-05)
    list(7.93505e-09 0.000153870749 0 4.67786845e-05)
    list(7.93625e-09 0.000153869854 0 2.38046386e-05)
    list(7.93825e-09 0.00015388896 0 1.98953027e-05)
    list(7.94025e-09 0.000153907801 0 1.93439393e-05)
    list(7.94225e-09 0.000153926426 0 1.90922811e-05)
    list(7.94425e-09 0.000153945559 0 1.89496212e-05)
    list(7.94625e-09 0.000153965433 0 1.8850172e-05)
    list(7.94825e-09 0.000153986064 0 1.87604819e-05)
    list(7.95025e-09 0.000154007391 0 1.86623889e-05)
    list(7.95225e-09 0.000154029329 0 1.85480236e-05)
    list(7.95425e-09 0.000154051798 0 1.8418751e-05)
    list(7.95625e-09 0.000154074724 0 1.82828146e-05)
    list(7.95825e-09 0.000154098051 0 1.81506887e-05)
    list(7.96025e-09 0.000154121737 0 1.80308349e-05)
    list(7.96225e-09 0.000154145753 0 1.79278938e-05)
    list(7.96425e-09 0.000154170075 0 1.78429964e-05)
    list(7.96625e-09 0.000154194687 0 1.77749588e-05)
    list(7.96825e-09 0.000154219569 0 1.77214618e-05)
    list(7.97025e-09 0.000154244706 0 1.76798762e-05)
    list(7.97225e-09 0.000154270082 0 1.76477243e-05)
    list(7.97425e-09 0.000154295683 0 1.76228804e-05)
    list(7.97625e-09 0.000154321494 0 1.76036196e-05)
    list(7.97825e-09 0.000154347503 0 1.75885896e-05)
    list(7.98025e-09 0.000154373701 0 1.75767542e-05)
    list(7.98225e-09 0.000154400078 0 1.75673305e-05)
    list(7.98425e-09 0.000154426627 0 1.75597322e-05)
    list(7.98625e-09 0.000154453342 0 1.75535224e-05)
    list(7.98825e-09 0.000154480217 0 1.7548376e-05)
    list(7.99025e-09 0.000154507248 0 1.75440512e-05)
    list(7.99225e-09 0.000154534433 0 1.75403675e-05)
    list(7.99425e-09 0.000154561768 0 1.75371897e-05)
    list(7.99625e-09 0.00015458925 0 1.75344159e-05)
    list(7.99825e-09 0.000154616878 0 1.75319688e-05)
    list(8e-09 0.000154641162 0 1.75293532e-05)
    list(8.00075e-09 0.000253053591 0.15 6.55276526e-06)
    list(8.00275e-09 0.000558568169 0.55 -5.67988081e-06)
    list(8.00475e-09 0.0011525059 0.95 1.87952555e-05)
    list(8.00535e-09 0.00128436012 1 2.76346142e-05)
    list(8.00725e-09 0.00135544199 1 1.22449827e-05)
    list(8.00925e-09 0.00135420767 1 1.01540091e-05)
    list(8.01125e-09 0.00134586045 1 9.608847e-06)
    list(8.01325e-09 0.00133708126 1 9.22984235e-06)
    list(8.01525e-09 0.00132832486 1 8.87908091e-06)
    list(8.01725e-09 0.00131962461 1 8.53912701e-06)
    list(8.01925e-09 0.00131098264 1 8.20181086e-06)
    list(8.02125e-09 0.00130239878 1 7.85590832e-06)
    list(8.02325e-09 0.00129387276 1 7.47943118e-06)
    list(8.02525e-09 0.00128540435 1 7.02756224e-06)
    list(8.02725e-09 0.00127699338 1 6.43898444e-06)
    list(8.02925e-09 0.00126863986 1 5.70722518e-06)
    list(8.03015e-09 0.00122824078 0.97 2.50400921e-05)
    list(8.03175e-09 0.000720543496 0.65 7.37990843e-06)
    list(8.03375e-09 0.000250375147 0.25 5.41420527e-05)
    list(8.03505e-09 7.71725375e-05 0 4.67770997e-05)
    list(8.03625e-09 7.71716885e-05 0 2.38045355e-05)
    list(8.03825e-09 7.7190875e-05 0 1.98961238e-05)
    list(8.04025e-09 7.72097955e-05 0 1.93447269e-05)
    list(8.04225e-09 7.72285003e-05 0 1.9092986e-05)
    list(8.04425e-09 7.7247712e-05 0 1.89502361e-05)
    list(8.04625e-09 7.72676642e-05 0 1.88506955e-05)
    list(8.04825e-09 7.72883739e-05 0 1.87609148e-05)
    list(8.05025e-09 7.73097791e-05 0 1.86627346e-05)
    list(8.05225e-09 7.73317965e-05 0 1.85482909e-05)
    list(8.05425e-09 7.73543436e-05 0 1.84189548e-05)
    list(8.05625e-09 7.73773485e-05 0 1.82829731e-05)
    list(8.05825e-09 7.74007543e-05 0 1.81508188e-05)
    list(8.06025e-09 7.74245196e-05 0 1.80309488e-05)
    list(8.06225e-09 7.74486145e-05 0 1.79279989e-05)
    list(8.06425e-09 7.74730168e-05 0 1.78430963e-05)
    list(8.06625e-09 7.74977078e-05 0 1.77750548e-05)
    list(8.06825e-09 7.75226702e-05 0 1.77215541e-05)
    list(8.07025e-09 7.75478877e-05 0 1.76799645e-05)
    list(8.07225e-09 7.75733444e-05 0 1.76478082e-05)
    list(8.07425e-09 7.75990255e-05 0 1.76229598e-05)
    list(8.07625e-09 7.76249174e-05 0 1.76036943e-05)
    list(8.07825e-09 7.76510082e-05 0 1.75886599e-05)
    list(8.08025e-09 7.76772873e-05 0 1.75768203e-05)
    list(8.08225e-09 7.77037459e-05 0 1.75673927e-05)
    list(8.08425e-09 7.77303766e-05 0 1.75597909e-05)
    list(8.08625e-09 7.77571732e-05 0 1.75535778e-05)
    list(8.08825e-09 7.77841304e-05 0 1.75484286e-05)
    list(8.09025e-09 7.78112443e-05 0 1.75441013e-05)
    list(8.09225e-09 7.78385113e-05 0 1.75404154e-05)
    list(8.09425e-09 7.78659286e-05 0 1.75372358e-05)
    list(8.09625e-09 7.7893494e-05 0 1.75344603e-05)
    list(8.09825e-09 7.79212054e-05 0 1.75320118e-05)
    list(8.1e-09 7.79455615e-05 0 1.75293946e-05)
    list(8.10075e-09 0.000176364628 0.15 6.55251535e-06)
    list(8.10275e-09 0.000482061858 0.55 -5.67575233e-06)
    list(8.10475e-09 0.00107650695 0.95 1.8793397e-05)
    list(8.10535e-09 0.00120851517 1 2.7634784e-05)
    list(8.10725e-09 0.00128008878 1 1.22448478e-05)
    list(8.10925e-09 0.00127938703 1 1.01467035e-05)
    list(8.11125e-09 0.00127153854 1 9.60186909e-06)
    list(8.11325e-09 0.00126325315 1 9.22354454e-06)
    list(8.11525e-09 0.00125498715 1 8.87341693e-06)
    list(8.11725e-09 0.00124677405 1 8.53403009e-06)
    list(8.11925e-09 0.001238616 1 8.19721996e-06)
    list(8.12125e-09 0.00123051286 1 7.85176972e-06)
    list(8.12325e-09 0.00122246437 1 7.47569888e-06)
    list(8.12525e-09 0.00121447032 1 7.0241986e-06)
    list(8.12725e-09 0.00120653059 1 6.43595571e-06)
    list(8.12925e-09 0.00119864517 1 5.70449178e-06)
    list(8.13015e-09 0.00115845184 0.97 2.5005137e-05)
    list(8.13175e-09 0.000651055801 0.65 7.35614671e-06)
    list(8.13375e-09 0.000181009539 0.25 5.41218592e-05)
    list(8.13505e-09 7.79825339e-06 0 4.67756648e-05)
    list(8.13625e-09 7.79744609e-06 0 2.38044422e-05)
    list(8.13825e-09 7.81670558e-06 0 1.98968664e-05)
    list(8.14025e-09 7.835698e-06 0 1.93454391e-05)
    list(8.14225e-09 7.8544742e-06 0 1.90936235e-05)
    list(8.14425e-09 7.87375721e-06 0 1.89507921e-05)
    list(8.14625e-09 7.89378056e-06 0 1.88511689e-05)
    list(8.14825e-09 7.91456133e-06 0 1.87613063e-05)
    list(8.15025e-09 7.93603764e-06 0 1.86630472e-05)
    list(8.15225e-09 7.95812611e-06 0 1.85485326e-05)
    list(8.15425e-09 7.98074428e-06 0 1.84191391e-05)
    list(8.15625e-09 8.00382031e-06 0 1.82831165e-05)
    list(8.15825e-09 8.02729748e-06 0 1.81509364e-05)
    list(8.16025e-09 8.05113426e-06 0 1.80310519e-05)
    list(8.16225e-09 8.07530095e-06 0 1.7928094e-05)
    list(8.16425e-09 8.09977518e-06 0 1.78431867e-05)
    list(8.16625e-09 8.12453829e-06 0 1.77751417e-05)
    list(8.16825e-09 8.14957311e-06 0 1.77216376e-05)
    list(8.17025e-09 8.17486317e-06 0 1.76800443e-05)
    list(8.17225e-09 8.20039266e-06 0 1.76478841e-05)
    list(8.17425e-09 8.22614673e-06 0 1.76230316e-05)
    list(8.17625e-09 8.25211185e-06 0 1.7603762e-05)
    list(8.17825e-09 8.27827598e-06 0 1.75887235e-05)
    list(8.18025e-09 8.30462868e-06 0 1.75768801e-05)
    list(8.18225e-09 8.33116105e-06 0 1.7567449e-05)
    list(8.18425e-09 8.35786565e-06 0 1.75598439e-05)
    list(8.18625e-09 8.38473627e-06 0 1.7553628e-05)
    list(8.18825e-09 8.41176783e-06 0 1.75484762e-05)
    list(8.19025e-09 8.43895612e-06 0 1.75441467e-05)
    list(8.19225e-09 8.46629773e-06 0 1.75404588e-05)
    list(8.19425e-09 8.49378984e-06 0 1.75372774e-05)
    list(8.19625e-09 8.52143013e-06 0 1.75345005e-05)
    list(8.19825e-09 8.54921667e-06 0 1.75320507e-05)
    list(8.2e-09 8.57363866e-06 0 1.75294322e-05)
    list(8.20075e-09 0.000106998707 0.15 6.55229218e-06)
    list(8.20275e-09 0.000412861306 0.55 -5.67201188e-06)
    list(8.20475e-09 0.0010077653 0.95 1.87917126e-05)
    list(8.20535e-09 0.00113991281 1 2.76349344e-05)
    list(8.20725e-09 0.00121191933 1 1.22447601e-05)
    list(8.20925e-09 0.00121171138 1 1.01401524e-05)
    list(8.21125e-09 0.00120431432 1 9.59561577e-06)
    list(8.21325e-09 0.00119647563 1 9.21790675e-06)
    list(8.21525e-09 0.00118865328 1 8.86835215e-06)
    list(8.21725e-09 0.00118088087 1 8.52947744e-06)
    list(8.21925e-09 0.00117316059 1 8.19312387e-06)
    list(8.22125e-09 0.00116549233 1 7.84808129e-06)
    list(8.22325e-09 0.00115787584 1 7.47237632e-06)
    list(8.22525e-09 0.00115031093 1 7.0212077e-06)
    list(8.22725e-09 0.0011427975 1 6.43326583e-06)
    list(8.22925e-09 0.00113533556 1 5.70206708e-06)
    list(8.23015e-09 0.00109532831 0.97 2.49735136e-05)
    list(8.23175e-09 0.000588204805 0.65 7.33465149e-06)
    list(8.23375e-09 0.00011826905 0.25 5.41035883e-05)
    list(8.23505e-09 -5.49500787e-05 0 4.67743656e-05)
    list(8.23625e-09 -5.49508483e-05 0 2.38043577e-05)
    list(8.23825e-09 -5.49315229e-05 0 1.9897538e-05)
    list(8.24025e-09 -5.49124656e-05 0 1.93460833e-05)
    list(8.24225e-09 -5.48936248e-05 0 1.90942e-05)
    list(8.24425e-09 -5.48742774e-05 0 1.8951295e-05)
    list(8.24625e-09 -5.48541898e-05 0 1.8851597e-05)
    list(8.24825e-09 -5.48333448e-05 0 1.87616603e-05)
    list(8.25025e-09 -5.48118043e-05 0 1.86633299e-05)
    list(8.25225e-09 -5.47896516e-05 0 1.85487511e-05)
    list(8.25425e-09 -5.47669692e-05 0 1.84193057e-05)
    list(8.25625e-09 -5.47438289e-05 0 1.82832461e-05)
    list(8.25825e-09 -5.47202873e-05 0 1.81510428e-05)
    list(8.26025e-09 -5.46963859e-05 0 1.80311451e-05)
    list(8.26225e-09 -5.46721544e-05 0 1.792818e-05)
    list(8.26425e-09 -5.46476152e-05 0 1.78432685e-05)
    list(8.26625e-09 -5.46227869e-05 0 1.77752203e-05)
    list(8.26825e-09 -5.45976866e-05 0 1.77217131e-05)
    list(8.27025e-09 -5.4572331e-05 0 1.76801166e-05)
    list(8.27225e-09 -5.45467358e-05 0 1.76479528e-05)
    list(8.27425e-09 -5.45209157e-05 0 1.76230965e-05)
    list(8.27625e-09 -5.44948845e-05 0 1.76038232e-05)
    list(8.27825e-09 -5.44686541e-05 0 1.75887811e-05)
    list(8.28025e-09 -5.44422349e-05 0 1.75769343e-05)
    list(8.28225e-09 -5.44156359e-05 0 1.75674999e-05)
    list(8.28425e-09 -5.43888645e-05 0 1.75598919e-05)
    list(8.28625e-09 -5.4361927e-05 0 1.75536734e-05)
    list(8.28825e-09 -5.43348283e-05 0 1.75485193e-05)
    list(8.29025e-09 -5.43075727e-05 0 1.75441877e-05)
    list(8.29225e-09 -5.42801637e-05 0 1.7540498e-05)
    list(8.29425e-09 -5.4252604e-05 0 1.75373151e-05)
    list(8.29625e-09 -5.4224896e-05 0 1.75345368e-05)
    list(8.29825e-09 -5.41970416e-05 0 1.75320859e-05)
    list(8.3e-09 -5.41725601e-05 0 1.75294661e-05)
    list(8.30075e-09 4.42579358e-05 0.15 6.55209325e-06)
    list(8.30275e-09 0.000350270241 0.55 -5.66862241e-06)
    list(8.30475e-09 0.000945589298 0.95 1.87901865e-05)
    list(8.30535e-09 0.00107786282 1 2.76350676e-05)
    list(8.30725e-09 0.00115025943 1 1.22446848e-05)
    list(8.30925e-09 0.00115049906 1 1.01458427e-05)
    list(8.31125e-09 0.00114351138 1 9.60006876e-06)
    list(8.31325e-09 0.00113607684 1 9.22183338e-06)
    list(8.31525e-09 0.00112865579 1 8.87185199e-06)
    list(8.31725e-09 0.00112128201 1 8.53260023e-06)
    list(8.31925e-09 0.00111395774 1 8.19591147e-06)
    list(8.32125e-09 0.00110668286 1 7.85057162e-06)
    list(8.32325e-09 0.00109945715 1 7.47460478e-06)
    list(8.32525e-09 0.00109228044 1 7.02320868e-06)
    list(8.32725e-09 0.00108515264 1 6.43506981e-06)
    list(8.32925e-09 0.00107807378 1 5.7036935e-06)
    list(8.33015e-09 0.00103823474 0.97 2.49447274e-05)
    list(8.33175e-09 0.000531357793 0.65 7.31505865e-06)
    list(8.33375e-09 6.15220529e-05 0.25 5.40869256e-05)
    list(8.33505e-09 -0.000111704164 0 4.67731971e-05)
    list(8.33625e-09 -0.000111704899 0 2.38042871e-05)
    list(8.33825e-09 -0.000111685515 0 1.98981504e-05)
    list(8.34025e-09 -0.000111666399 0 1.93466704e-05)
    list(8.34225e-09 -0.0001116475 0 1.90947255e-05)
    list(8.34425e-09 -0.000111628094 0 1.89517535e-05)
    list(8.34625e-09 -0.000111607948 0 1.88519875e-05)
    list(8.34825e-09 -0.000111587045 0 1.87619834e-05)
    list(8.35025e-09 -0.000111565447 0 1.86635882e-05)
    list(8.35225e-09 -0.000111543236 0 1.85489511e-05)
    list(8.35425e-09 -0.000111520496 0 1.84194584e-05)
    list(8.35625e-09 -0.000111497298 0 1.82833652e-05)
    list(8.35825e-09 -0.000111473698 0 1.81511407e-05)
    list(8.36025e-09 -0.000111449738 0 1.80312308e-05)
    list(8.36225e-09 -0.000111425448 0 1.79282591e-05)
    list(8.36425e-09 -0.00011140085 0 1.78433437e-05)
    list(8.36625e-09 -0.000111375963 0 1.77752925e-05)
    list(8.36825e-09 -0.000111350804 0 1.77217824e-05)
    list(8.37025e-09 -0.000111325389 0 1.76801827e-05)
    list(8.37225e-09 -0.000111299734 0 1.76480156e-05)
    list(8.37425e-09 -0.000111273855 0 1.76231559e-05)
    list(8.37625e-09 -0.000111247764 0 1.76038792e-05)
    list(8.37825e-09 -0.000111221474 0 1.75888337e-05)
    list(8.38025e-09 -0.000111194994 0 1.75769837e-05)
    list(8.38225e-09 -0.000111168335 0 1.75675464e-05)
    list(8.38425e-09 -0.000111141504 0 1.75599358e-05)
    list(8.38625e-09 -0.000111114506 0 1.75537148e-05)
    list(8.38825e-09 -0.000111087346 0 1.75485586e-05)
    list(8.39025e-09 -0.00011106003 0 1.75442251e-05)
    list(8.39225e-09 -0.00011103256 0 1.75405338e-05)
    list(8.39425e-09 -0.000111004939 0 1.75373494e-05)
    list(8.39625e-09 -0.00011097717 0 1.75345699e-05)
    list(8.39825e-09 -0.000110949255 0 1.75321179e-05)
    list(8.4e-09 -0.000110924719 0 1.7529497e-05)
    list(8.40075e-09 -1.24893154e-05 0.15 6.55191627e-06)
    list(8.40275e-09 0.000293658503 0.55 -5.6655504e-06)
    list(8.40475e-09 0.000889352971 0.95 1.87888042e-05)
    list(8.40535e-09 0.00102174046 1 2.76351853e-05)
    list(8.40725e-09 0.00109448994 1 1.22446163e-05)
    list(8.40925e-09 0.00109513437 1 1.01524489e-05)
    list(8.41125e-09 0.00108851716 1 9.60536611e-06)
    list(8.41325e-09 0.00108144823 1 9.22651846e-06)
    list(8.41525e-09 0.00107439019 1 8.87603226e-06)
    list(8.41725e-09 0.00106737703 1 8.53633384e-06)
    list(8.41925e-09 0.00106041098 1 8.19924789e-06)
    list(8.42125e-09 0.00105349196 1 7.85355545e-06)
    list(8.42325e-09 0.00104661976 1 7.47727728e-06)
    list(8.42525e-09 0.00103979421 1 7.02560915e-06)
    list(8.42725e-09 0.00103301526 1 6.43723317e-06)
    list(8.42925e-09 0.00102628294 1 5.70564383e-06)
    list(8.43015e-09 0.000986596045 0.97 2.49186638e-05)
    list(8.43175e-09 0.000479942143 0.65 7.29731705e-06)
    list(8.43375e-09 1.0196912e-05 0.25 5.40718341e-05)
    list(8.43505e-09 -0.000163035713 0 4.67721402e-05)
    list(8.43625e-09 -0.000163036418 0 2.38042238e-05)
    list(8.43825e-09 -0.00016301698 0 1.98987049e-05)
    list(8.44025e-09 -0.000162997811 0 1.93472018e-05)
    list(8.44225e-09 -0.000162978859 0 1.90952012e-05)
    list(8.44425e-09 -0.000162959401 0 1.89521685e-05)
    list(8.44625e-09 -0.000162939203 0 1.8852341e-05)
    list(8.44825e-09 -0.000162918248 0 1.87622759e-05)
    list(8.45025e-09 -0.000162896597 0 1.86638221e-05)
    list(8.45225e-09 -0.000162874334 0 1.85491322e-05)
    list(8.45425e-09 -0.000162851542 0 1.84195968e-05)
    list(8.45625e-09 -0.000162828291 0 1.82834731e-05)
    list(8.45825e-09 -0.000162804639 0 1.81512294e-05)
    list(8.46025e-09 -0.000162780626 0 1.80313086e-05)
    list(8.46225e-09 -0.000162756284 0 1.79283308e-05)
    list(8.46425e-09 -0.000162731633 0 1.78434118e-05)
    list(8.46625e-09 -0.000162706693 0 1.77753579e-05)
    list(8.46825e-09 -0.00016268148 0 1.77218451e-05)
    list(8.47025e-09 -0.000162656012 0 1.76802427e-05)
    list(8.47225e-09 -0.000162630304 0 1.76480726e-05)
    list(8.47425e-09 -0.00016260437 0 1.76232098e-05)
    list(8.47625e-09 -0.000162578226 0 1.76039299e-05)
    list(8.47825e-09 -0.000162551881 0 1.75888814e-05)
    list(8.48025e-09 -0.000162525348 0 1.75770285e-05)
    list(8.48225e-09 -0.000162498635 0 1.75675885e-05)
    list(8.48425e-09 -0.000162471748 0 1.75599754e-05)
    list(8.48625e-09 -0.000162444696 0 1.75537523e-05)
    list(8.48825e-09 -0.000162417482 0 1.75485941e-05)
    list(8.49025e-09 -0.000162390111 0 1.75442589e-05)
    list(8.49225e-09 -0.000162362586 0 1.75405662e-05)
    list(8.49425e-09 -0.00016233491 0 1.75373805e-05)
    list(8.49625e-09 -0.000162307086 0 1.75345999e-05)
    list(8.49825e-09 -0.000162279115 0 1.75321469e-05)
    list(8.5e-09 -0.000162254531 0 1.7529525e-05)
    list(8.50075e-09 -6.38146893e-05 0.15 6.55175916e-06)
    list(8.50275e-09 0.000242455784 0.55 -5.66276552e-06)
    list(8.50475e-09 0.000838489796 0.95 1.87875526e-05)
    list(8.50535e-09 0.000970980381 1 2.76352891e-05)
    list(8.50725e-09 0.00104404903 1 1.22445539e-05)
    list(8.50925e-09 0.00104505964 1 1.01584249e-05)
    list(8.51125e-09 0.00103877755 1 9.6101578e-06)
    list(8.51325e-09 0.00103203935 1 9.23075631e-06)
    list(8.51525e-09 0.0010253097 1 8.87981346e-06)
    list(8.51725e-09 0.00101862274 1 8.53971101e-06)
    list(8.51925e-09 0.00101198074 1 8.20226577e-06)
    list(8.52125e-09 0.00100538362 1 7.85625439e-06)
    list(8.52325e-09 0.000998831198 1 7.47969461e-06)
    list(8.52525e-09 0.000992323315 1 7.02778042e-06)
    list(8.52725e-09 0.000985859916 1 6.43918994e-06)
    list(8.52925e-09 0.000979441066 1 5.70740791e-06)
    list(8.53015e-09 0.00093989181 0.97 2.48950856e-05)
    list(8.53175e-09 0.00043343967 0.65 7.28126869e-06)
    list(8.53375e-09 -3.622366e-05 0.25 5.40581805e-05)
    list(8.53505e-09 -0.00020946208 0 4.67711834e-05)
    list(8.53625e-09 -0.000209462758 0 2.38041664e-05)
    list(8.53825e-09 -0.000209443271 0 1.98992061e-05)
    list(8.54025e-09 -0.000209424054 0 1.93476824e-05)
    list(8.54225e-09 -0.000209405055 0 1.90956313e-05)
    list(8.54425e-09 -0.00020938555 0 1.89525437e-05)
    list(8.54625e-09 -0.000209365305 0 1.88526606e-05)
    list(8.54825e-09 -0.000209344302 0 1.87625403e-05)
    list(8.55025e-09 -0.000209322605 0 1.86640335e-05)
    list(8.55225e-09 -0.000209300295 0 1.85492959e-05)
    list(8.55425e-09 -0.000209277455 0 1.84197219e-05)
    list(8.55625e-09 -0.000209254157 0 1.82835707e-05)
    list(8.55825e-09 -0.000209230457 0 1.81513096e-05)
    list(8.56025e-09 -0.000209206398 0 1.80313789e-05)
    list(8.56225e-09 -0.000209182007 0 1.79283957e-05)
    list(8.56425e-09 -0.000209157309 0 1.78434734e-05)
    list(8.56625e-09 -0.000209132321 0 1.7775417e-05)
    list(8.56825e-09 -0.00020910706 0 1.77219019e-05)
    list(8.57025e-09 -0.000209081544 0 1.7680297e-05)
    list(8.57225e-09 -0.000209055787 0 1.76481241e-05)
    list(8.57425e-09 -0.000209029806 0 1.76232585e-05)
    list(8.57625e-09 -0.000209003612 0 1.76039757e-05)
    list(8.57825e-09 -0.000208977219 0 1.75889245e-05)
    list(8.58025e-09 -0.000208950637 0 1.7577069e-05)
    list(8.58225e-09 -0.000208923875 0 1.75676267e-05)
    list(8.58425e-09 -0.00020889694 0 1.75600114e-05)
    list(8.58625e-09 -0.000208869838 0 1.75537863e-05)
    list(8.58825e-09 -0.000208842575 0 1.75486263e-05)
    list(8.59025e-09 -0.000208815154 0 1.75442896e-05)
    list(8.59225e-09 -0.00020878758 0 1.75405954e-05)
    list(8.59425e-09 -0.000208759854 0 1.75374086e-05)
    list(8.59625e-09 -0.00020873198 0 1.7534627e-05)
    list(8.59825e-09 -0.000208703959 0 1.75321732e-05)
    list(8.6e-09 -0.000208679332 0 1.75295503e-05)
    list(8.60075e-09 -0.000110235477 0.15 6.55162006e-06)
    list(8.60275e-09 0.000196146005 0.55 -5.66024033e-06)
    list(8.60475e-09 0.000792487119 0.95 1.87864195e-05)
    list(8.60535e-09 0.000925070952 1 2.76353803e-05)
    list(8.60725e-09 0.000998428303 1 1.2244497e-05)
    list(8.60925e-09 0.000999770136 1 1.01638306e-05)
    list(8.61125e-09 0.000993791191 1 9.61449203e-06)
    list(8.61325e-09 0.000987352149 1 9.23458956e-06)
    list(8.61525e-09 0.000980919549 1 8.88323364e-06)
    list(8.61725e-09 0.000974527667 1 8.54276571e-06)
    list(8.61925e-09 0.000968178787 1 8.20499547e-06)
    list(8.62125e-09 0.000961872853 1 7.85869559e-06)
    list(8.62325e-09 0.000955609684 1 7.48188108e-06)
    list(8.62525e-09 0.000949389143 1 7.02974431e-06)
    list(8.62725e-09 0.000943211184 1 6.44095984e-06)
    list(8.62925e-09 0.000937075884 1 5.70900351e-06)
    list(8.63015e-09 0.000897651125 0.97 2.48737556e-05)
    list(8.63175e-09 0.000391381491 0.65 7.26675194e-06)
    list(8.63375e-09 -7.82077342e-05 0.25 5.40458279e-05)
    list(8.63505e-09 -0.000251451395 0 4.67703173e-05)
    list(8.63625e-09 -0.000251452047 0 2.38041142e-05)
    list(8.63825e-09 -0.000251432517 0 1.98996593e-05)
    list(8.64025e-09 -0.000251413257 0 1.93481168e-05)
    list(8.64225e-09 -0.000251394216 0 1.90960202e-05)
    list(8.64425e-09 -0.000251374668 0 1.8952883e-05)
    list(8.64625e-09 -0.00025135438 0 1.88529495e-05)
    list(8.64825e-09 -0.000251333336 0 1.87627794e-05)
    list(8.65025e-09 -0.000251311595 0 1.86642246e-05)
    list(8.65225e-09 -0.000251289243 0 1.85494439e-05)
    list(8.65425e-09 -0.000251266361 0 1.8419835e-05)
    list(8.65625e-09 -0.00025124302 0 1.82836589e-05)
    list(8.65825e-09 -0.000251219278 0 1.81513821e-05)
    list(8.66025e-09 -0.000251195176 0 1.80314424e-05)
    list(8.66225e-09 -0.000251170742 0 1.79284544e-05)
    list(8.66425e-09 -0.000251146001 0 1.78435291e-05)
    list(8.66625e-09 -0.00025112097 0 1.77754705e-05)
    list(8.66825e-09 -0.000251095666 0 1.77219533e-05)
    list(8.67025e-09 -0.000251070106 0 1.7680346e-05)
    list(8.67225e-09 -0.000251044306 0 1.76481707e-05)
    list(8.67425e-09 -0.000251018281 0 1.76233025e-05)
    list(8.67625e-09 -0.000250992044 0 1.76040172e-05)
    list(8.67825e-09 -0.000250965607 0 1.75889635e-05)
    list(8.68025e-09 -0.000250938981 0 1.75771057e-05)
    list(8.68225e-09 -0.000250912174 0 1.75676611e-05)
    list(8.68425e-09 -0.000250885195 0 1.75600438e-05)
    list(8.68625e-09 -0.000250858049 0 1.7553817e-05)
    list(8.68825e-09 -0.000250830741 0 1.75486554e-05)
    list(8.69025e-09 -0.000250803276 0 1.75443173e-05)
    list(8.69225e-09 -0.000250775657 0 1.75406219e-05)
    list(8.69425e-09 -0.000250747887 0 1.7537434e-05)
    list(8.69625e-09 -0.000250719968 0 1.75346515e-05)
    list(8.69825e-09 -0.000250691903 0 1.75321969e-05)
    list(8.7e-09 -0.000250667236 0 1.75295731e-05)
    list(8.70075e-09 -0.000152219752 0.15 6.55149727e-06)
    list(8.70275e-09 0.000154262191 0.55 -5.65795003e-06)
    list(8.70475e-09 0.000750881066 0.95 1.87853939e-05)
    list(8.70535e-09 0.00088354924 1 2.76354603e-05)
    list(8.70725e-09 0.000957167714 1 1.22444452e-05)
    list(8.70925e-09 0.00095880915 1 1.01687204e-05)
    list(8.71125e-09 0.000953104412 1 9.61841244e-06)
    list(8.71325e-09 0.000946935976 1 9.23805679e-06)
    list(8.71525e-09 0.000940772068 1 8.88632722e-06)
    list(8.71725e-09 0.000934647093 1 8.54552869e-06)
    list(8.71925e-09 0.000928563352 1 8.20746448e-06)
    list(8.72125e-09 0.000922520804 1 7.86090364e-06)
    list(8.72325e-09 0.000916519277 1 7.48385871e-06)
    list(8.72525e-09 0.000910558647 1 7.03152062e-06)
    list(8.72725e-09 0.000904638878 1 6.44256066e-06)
    list(8.72925e-09 0.000898760058 1 5.71044669e-06)
    list(8.73015e-09 0.000859447833 0.97 2.48544516e-05)
    list(8.73175e-09 0.000353343341 0.65 7.25360708e-06)
    list(8.73375e-09 -0.000116178833 0.25 5.40346321e-05)
    list(8.73505e-09 -0.00028942723 0 4.67695306e-05)
    list(8.73625e-09 -0.00028942786 0 2.38040658e-05)
    list(8.73825e-09 -0.00028940829 0 1.9900068e-05)
    list(8.74025e-09 -0.000289388992 0 1.93485086e-05)
    list(8.74225e-09 -0.000289369912 0 1.90963708e-05)
    list(8.74425e-09 -0.000289350326 0 1.89531889e-05)
    list(8.74625e-09 -0.00028933 0 1.88532099e-05)
    list(8.74825e-09 -0.000289308917 0 1.87629947e-05)
    list(8.75025e-09 -0.000289287139 0 1.86643966e-05)
    list(8.75225e-09 -0.000289264748 0 1.85495769e-05)
    list(8.75425e-09 -0.000289241828 0 1.84199364e-05)
    list(8.75625e-09 -0.000289218449 0 1.82837378e-05)
    list(8.75825e-09 -0.000289194669 0 1.81514469e-05)
    list(8.76025e-09 -0.000289170528 0 1.80314992e-05)
    list(8.76225e-09 -0.000289146056 0 1.79285067e-05)
    list(8.76425e-09 -0.000289121276 0 1.78435789e-05)
    list(8.76625e-09 -0.000289096206 0 1.77755183e-05)
    list(8.76825e-09 -0.000289070863 0 1.77219992e-05)
    list(8.77025e-09 -0.000289045264 0 1.76803899e-05)
    list(8.77225e-09 -0.000289019425 0 1.76482124e-05)
    list(8.77425e-09 -0.000288993361 0 1.76233419e-05)
    list(8.77625e-09 -0.000288967084 0 1.76040544e-05)
    list(8.77825e-09 -0.000288940608 0 1.75889984e-05)
    list(8.78025e-09 -0.000288913942 0 1.75771385e-05)
    list(8.78225e-09 -0.000288887096 0 1.7567692e-05)
    list(8.78425e-09 -0.000288860077 0 1.75600729e-05)
    list(8.78625e-09 -0.000288832891 0 1.75538445e-05)
    list(8.78825e-09 -0.000288805544 0 1.75486815e-05)
    list(8.79025e-09 -0.000288778039 0 1.75443422e-05)
    list(8.79225e-09 -0.00028875038 0 1.75406457e-05)
    list(8.79425e-09 -0.000288722569 0 1.75374569e-05)
    list(8.79625e-09 -0.00028869461 0 1.75346735e-05)
    list(8.79825e-09 -0.000288666504 0 1.75322182e-05)
    list(8.8e-09 -0.000288641801 0 1.75295938e-05)
    list(8.80075e-09 -0.000190191035 0.15 6.55138924e-06)
    list(8.80275e-09 0.000116381817 0.55 -5.65587215e-06)
    list(8.80475e-09 0.000713251913 0.95 1.8784466e-05)
    list(8.80535e-09 0.000845996373 1 2.76355301e-05)
    list(8.80725e-09 0.000919851022 1 1.2244398e-05)
    list(8.80925e-09 0.000921763452 1 1.01731433e-05)
    list(8.81125e-09 0.00091630674 1 9.62195849e-06)
    list(8.81325e-09 0.000910383072 1 9.24119292e-06)
    list(8.81525e-09 0.000904462201 1 8.88912536e-06)
    list(8.81725e-09 0.000898578646 1 8.54802779e-06)
    list(8.81925e-09 0.000892734729 1 8.20969766e-06)
    list(8.82125e-09 0.000886930417 1 7.86290078e-06)
    list(8.82325e-09 0.000881165549 1 7.48564743e-06)
    list(8.82525e-09 0.000875440011 1 7.03312724e-06)
    list(8.82725e-09 0.000869753778 1 6.44400856e-06)
    list(8.82925e-09 0.000864106947 1 5.71175199e-06)
    list(8.83015e-09 0.000824896422 0.97 2.4836979e-05)
    list(8.83175e-09 0.00031894137 0.65 7.24170134e-06)
    list(8.83375e-09 -0.000150520138 0.25 5.40244804e-05)
    list(8.83505e-09 -0.000323772815 0 4.67688155e-05)
    list(8.83625e-09 -0.000323773425 0 2.38040207e-05)
    list(8.83825e-09 -0.000323753821 0 1.99004364e-05)
    list(8.84025e-09 -0.000323734488 0 1.93488618e-05)
    list(8.84225e-09 -0.000323715373 0 1.90966868e-05)
    list(8.84425e-09 -0.000323695753 0 1.89534644e-05)
    list(8.84625e-09 -0.000323675393 0 1.88534443e-05)
    list(8.84825e-09 -0.000323654275 0 1.87631884e-05)
    list(8.85025e-09 -0.000323632463 0 1.86645511e-05)
    list(8.85225e-09 -0.000323610038 0 1.85496961e-05)
    list(8.85425e-09 -0.000323587083 0 1.84200272e-05)
    list(8.85625e-09 -0.00032356367 0 1.82838083e-05)
    list(8.85825e-09 -0.000323539855 0 1.81515047e-05)
    list(8.86025e-09 -0.000323515679 0 1.80315497e-05)
    list(8.86225e-09 -0.000323491173 0 1.79285533e-05)
    list(8.86425e-09 -0.000323466358 0 1.78436232e-05)
    list(8.86625e-09 -0.000323441253 0 1.77755609e-05)
    list(8.86825e-09 -0.000323415876 0 1.772204e-05)
    list(8.87025e-09 -0.000323390242 0 1.7680429e-05)
    list(8.87225e-09 -0.000323364367 0 1.76482496e-05)
    list(8.87425e-09 -0.000323338268 0 1.76233771e-05)
    list(8.87625e-09 -0.000323311956 0 1.76040875e-05)
    list(8.87825e-09 -0.000323285444 0 1.75890296e-05)
    list(8.88025e-09 -0.000323258743 0 1.75771678e-05)
    list(8.88225e-09 -0.000323231861 0 1.75677196e-05)
    list(8.88425e-09 -0.000323204806 0 1.7560099e-05)
    list(8.88625e-09 -0.000323177584 0 1.75538691e-05)
    list(8.88825e-09 -0.000323150201 0 1.75487049e-05)
    list(8.89025e-09 -0.00032312266 0 1.75443644e-05)
    list(8.89225e-09 -0.000323094964 0 1.75406671e-05)
    list(8.89425e-09 -0.000323067118 0 1.75374774e-05)
    list(8.89625e-09 -0.000323039122 0 1.75346933e-05)
    list(8.89825e-09 -0.00032301098 0 1.75322374e-05)
    list(8.9e-09 -0.000322986246 0 1.75296123e-05)
    list(8.90075e-09 -0.000224532512 0.15 6.55129458e-06)
    list(8.90275e-09 8.21226023e-05 0.55 -5.65398639e-06)
    list(8.90475e-09 0.000679219917 0.95 1.87836265e-05)
    list(8.90535e-09 0.000812033375 1 2.76355908e-05)
    list(8.90725e-09 0.000886101631 1 1.22443549e-05)
    list(8.90925e-09 0.00088825917 1 1.0177144e-05)
    list(8.91125e-09 0.000883026797 1 9.62516591e-06)
    list(8.91325e-09 0.000877324523 1 9.24402955e-06)
    list(8.91525e-09 0.000871623478 1 8.89165626e-06)
    list(8.91725e-09 0.000865958289 1 8.55028819e-06)
    list(8.91925e-09 0.000860331291 1 8.21171752e-06)
    list(8.92125e-09 0.000854742462 1 7.86470713e-06)
    list(8.92325e-09 0.00084919165 1 7.48726525e-06)
    list(8.92525e-09 0.000843678751 1 7.03458035e-06)
    list(8.92725e-09 0.000838203749 1 6.4453181e-06)
    list(8.92925e-09 0.00083276675 1 5.71293256e-06)
    list(8.93015e-09 0.00079364821 0.97 2.48211719e-05)
    list(8.93175e-09 0.000287828321 0.65 7.23093149e-06)
    list(8.93375e-09 -0.000181578305 0.25 5.40152957e-05)
    list(8.93505e-09 -0.000354834854 0 4.67681681e-05)
    list(8.93625e-09 -0.000354835446 0 2.38039796e-05)
    list(8.93825e-09 -0.00035481581 0 1.99007693e-05)
    list(8.94025e-09 -0.000354796446 0 1.93491811e-05)
    list(8.94225e-09 -0.0003547773 0 1.90969725e-05)
    list(8.94425e-09 -0.000354757649 0 1.89537134e-05)
    list(8.94625e-09 -0.000354737258 0 1.88536562e-05)
    list(8.94825e-09 -0.00035471611 0 1.87633635e-05)
    list(8.95025e-09 -0.000354694266 0 1.86646908e-05)
    list(8.95225e-09 -0.00035467181 0 1.8549804e-05)
    list(8.95425e-09 -0.000354648825 0 1.84201093e-05)
    list(8.95625e-09 -0.000354625381 0 1.82838721e-05)
    list(8.95825e-09 -0.000354601535 0 1.81515569e-05)
    list(8.96025e-09 -0.000354577328 0 1.80315954e-05)
    list(8.96225e-09 -0.000354552791 0 1.79285954e-05)
    list(8.96425e-09 -0.000354527945 0 1.78436632e-05)
    list(8.96625e-09 -0.000354502809 0 1.77755993e-05)
    list(8.96825e-09 -0.0003544774 0 1.7722077e-05)
    list(8.97025e-09 -0.000354451734 0 1.76804643e-05)
    list(8.97225e-09 -0.000354425828 0 1.76482832e-05)
    list(8.97425e-09 -0.000354399697 0 1.76234089e-05)
    list(8.97625e-09 -0.000354373353 0 1.76041174e-05)
    list(8.97825e-09 -0.000354346809 0 1.75890577e-05)
    list(8.98025e-09 -0.000354320076 0 1.75771942e-05)
    list(8.98225e-09 -0.000354293162 0 1.75677445e-05)
    list(8.98425e-09 -0.000354266075 0 1.75601225e-05)
    list(8.98625e-09 -0.000354238821 0 1.75538913e-05)
    list(8.98825e-09 -0.000354211406 0 1.7548726e-05)
    list(8.99025e-09 -0.000354183832 0 1.75443846e-05)
    list(8.99225e-09 -0.000354156104 0 1.75406863e-05)
    list(8.99425e-09 -0.000354128225 0 1.75374959e-05)
    list(8.99625e-09 -0.000354100197 0 1.75347112e-05)
    list(8.99825e-09 -0.000354072022 0 1.75322548e-05)
    list(9e-09 -0.000354047259 0 1.7529629e-05)
    list(9.00075e-09 -0.000255590843 0.15 6.55121201e-06)
    list(9.00275e-09 5.11387055e-05 0.55 -5.6522744e-06)
    list(9.00475e-09 0.00064844153 0.95 1.87828672e-05)
    list(9.00535e-09 0.000781317394 1 2.76356433e-05)
    list(9.00725e-09 0.000855578841 1 1.22443154e-05)
    list(9.00925e-09 0.000857958072 1 1.01807626e-05)
    list(9.01125e-09 0.000852928612 1 9.62806702e-06)
    list(9.01325e-09 0.000847426583 1 9.24659526e-06)
    list(9.01525e-09 0.000841924367 1 8.89394542e-06)
    list(9.01725e-09 0.000836456684 1 8.55233267e-06)
    list(9.01925e-09 0.000831025884 1 8.21354443e-06)
    list(9.02125e-09 0.000825631954 1 7.8663409e-06)
    list(9.02325e-09 0.000820274752 1 7.4887285e-06)
    list(9.02525e-09 0.000814954179 1 7.03589462e-06)
    list(9.02725e-09 0.000809670229 1 6.44650251e-06)
    list(9.02925e-09 0.000804423017 1 5.71400031e-06)
    list(9.03015e-09 0.000765387675 0.97 2.48068712e-05)
    list(9.03175e-09 0.000259690033 0.65 7.22118901e-06)
    list(9.03375e-09 -0.000209666949 0.25 5.40069855e-05)
    list(9.03505e-09 -0.000382926998 0 4.6767582e-05)
    list(9.03625e-09 -0.000382927574 0 2.38039422e-05)
    list(9.03825e-09 -0.000382907909 0 1.99010702e-05)
    list(9.04025e-09 -0.000382888517 0 1.93494696e-05)
    list(9.04225e-09 -0.000382869344 0 1.90972306e-05)
    list(9.04425e-09 -0.000382849665 0 1.89539385e-05)
    list(9.04625e-09 -0.000382829246 0 1.88538478e-05)
    list(9.04825e-09 -0.00038280807 0 1.87635218e-05)
    list(9.05025e-09 -0.000382786199 0 1.8664817e-05)
    list(9.05225e-09 -0.000382763716 0 1.85499014e-05)
    list(9.05425e-09 -0.000382740703 0 1.84201834e-05)
    list(9.05625e-09 -0.000382717231 0 1.82839296e-05)
    list(9.05825e-09 -0.000382693357 0 1.81516041e-05)
    list(9.06025e-09 -0.000382669123 0 1.80316366e-05)
    list(9.06225e-09 -0.000382644558 0 1.79286335e-05)
    list(9.06425e-09 -0.000382619684 0 1.78436994e-05)
    list(9.06625e-09 -0.000382594519 0 1.77756341e-05)
    list(9.06825e-09 -0.000382569082 0 1.77221104e-05)
    list(9.07025e-09 -0.000382543388 0 1.76804963e-05)
    list(9.07225e-09 -0.000382517454 0 1.76483136e-05)
    list(9.07425e-09 -0.000382491294 0 1.76234376e-05)
    list(9.07625e-09 -0.000382464922 0 1.76041445e-05)
    list(9.07825e-09 -0.00038243835 0 1.75890832e-05)
    list(9.08025e-09 -0.000382411588 0 1.75772182e-05)
    list(9.08225e-09 -0.000382384645 0 1.75677671e-05)
    list(9.08425e-09 -0.000382357529 0 1.75601438e-05)
    list(9.08625e-09 -0.000382330246 0 1.75539115e-05)
    list(9.08825e-09 -0.000382302802 0 1.75487451e-05)
    list(9.09025e-09 -0.000382275199 0 1.75444028e-05)
    list(9.09225e-09 -0.000382247442 0 1.75407038e-05)
    list(9.09425e-09 -0.000382219534 0 1.75375127e-05)
    list(9.09625e-09 -0.000382191477 0 1.75347274e-05)
    list(9.09825e-09 -0.000382163272 0 1.75322705e-05)
    list(9.1e-09 -0.000382138483 0 1.75296442e-05)
    list(9.10075e-09 -0.00028367964 0.15 6.55114038e-06)
    list(9.10275e-09 2.31172546e-05 0.55 -5.65071957e-06)
    list(9.10475e-09 0.000620605954 0.95 1.87821807e-05)
    list(9.10535e-09 0.000753538263 1 2.76356884e-05)
    list(9.10725e-09 0.000827974433 1 1.22442794e-05)
    list(9.10925e-09 0.000830554173 1 1.01840357e-05)
    list(9.11125e-09 0.000825708239 1 9.63069107e-06)
    list(9.11325e-09 0.000820387326 1 9.24891593e-06)
    list(9.11525e-09 0.000815064942 1 8.89601593e-06)
    list(9.11725e-09 0.000809775896 1 8.55418185e-06)
    list(9.11925e-09 0.00080452255 1 8.2151968e-06)
    list(9.12125e-09 0.0007993049 1 7.86781857e-06)
    list(9.12325e-09 0.000794122808 1 7.49005193e-06)
    list(9.12525e-09 0.000788976187 1 7.03708329e-06)
    list(9.12725e-09 0.000783865036 1 6.44757373e-06)
    list(9.12925e-09 0.000778789477 1 5.71496601e-06)
    list(9.13015e-09 0.000739829384 0.97 2.4793933e-05)
    list(9.13175e-09 0.000234242303 0.65 7.21237573e-06)
    list(9.13375e-09 -0.000235069773 0.25 5.39994666e-05)
    list(9.13505e-09 -0.000408332989 0 4.67670514e-05)
    list(9.13625e-09 -0.00040833355 0 2.38039082e-05)
    list(9.13825e-09 -0.00040831386 0 1.99013421e-05)
    list(9.14025e-09 -0.000408294443 0 1.93497304e-05)
    list(9.14225e-09 -0.000408275245 0 1.9097464e-05)
    list(9.14425e-09 -0.000408255541 0 1.8954142e-05)
    list(9.14625e-09 -0.000408235097 0 1.88540209e-05)
    list(9.14825e-09 -0.000408213897 0 1.87636648e-05)
    list(9.15025e-09 -0.000408192001 0 1.86649311e-05)
    list(9.15225e-09 -0.000408169493 0 1.85499895e-05)
    list(9.15425e-09 -0.000408146455 0 1.84202504e-05)
    list(9.15625e-09 -0.000408122958 0 1.82839817e-05)
    list(9.15825e-09 -0.00040809906 0 1.81516467e-05)
    list(9.16025e-09 -0.000408074801 0 1.80316739e-05)
    list(9.16225e-09 -0.00040805021 0 1.79286679e-05)
    list(9.16425e-09 -0.000408025311 0 1.78437321e-05)
    list(9.16625e-09 -0.000408000122 0 1.77756655e-05)
    list(9.16825e-09 -0.000407974659 0 1.77221406e-05)
    list(9.17025e-09 -0.00040794894 0 1.76805252e-05)
    list(9.17225e-09 -0.00040792298 0 1.7648341e-05)
    list(9.17425e-09 -0.000407896795 0 1.76234636e-05)
    list(9.17625e-09 -0.000407870397 0 1.7604169e-05)
    list(9.17825e-09 -0.000407843799 0 1.75891063e-05)
    list(9.18025e-09 -0.000407817012 0 1.75772399e-05)
    list(9.18225e-09 -0.000407790043 0 1.75677875e-05)
    list(9.18425e-09 -0.000407762902 0 1.7560163e-05)
    list(9.18625e-09 -0.000407735593 0 1.75539297e-05)
    list(9.18825e-09 -0.000407708122 0 1.75487624e-05)
    list(9.19025e-09 -0.000407680494 0 1.75444193e-05)
    list(9.19225e-09 -0.000407652711 0 1.75407196e-05)
    list(9.19425e-09 -0.000407624776 0 1.75375279e-05)
    list(9.19625e-09 -0.000407596693 0 1.75347421e-05)
    list(9.19825e-09 -0.000407568462 0 1.75322847e-05)
    list(9.2e-09 -0.00040754365 0 1.75296579e-05)
    list(9.20075e-09 -0.000309082613 0.15 6.55107865e-06)
    list(9.20275e-09 -2.22478471e-06 0.55 -5.64930686e-06)
    list(9.20475e-09 0.000595432034 0.95 1.878156e-05)
    list(9.20535e-09 0.000728415392 1 2.76357269e-05)
    list(9.20725e-09 0.00080300958 1 1.22442464e-05)
    list(9.20925e-09 0.000805770668 1 1.01869961e-05)
    list(9.21125e-09 0.000801090723 1 9.63306451e-06)
    list(9.21325e-09 0.00079593362 1 9.25101495e-06)
    list(9.21525e-09 0.000790773886 1 8.89788866e-06)
    list(9.21725e-09 0.000785646407 1 8.55585437e-06)
    list(9.21925e-09 0.000780553559 1 8.2166913e-06)
    list(9.22125e-09 0.000775495343 1 7.86915506e-06)
    list(9.22325e-09 0.00077047163 1 7.4912489e-06)
    list(9.22525e-09 0.000765482338 1 7.03815836e-06)
    list(9.22725e-09 0.000760527473 1 6.44854256e-06)
    list(9.22925e-09 0.000755607165 1 5.7158394e-06)
    list(9.23015e-09 0.000716715129 0.97 2.47822271e-05)
    list(9.23175e-09 0.000211228038 0.65 7.20440285e-06)
    list(9.23375e-09 -0.000258043421 0.25 5.39926632e-05)
    list(9.23505e-09 -0.0004313095 0 4.6766571e-05)
    list(9.23625e-09 -0.000431310049 0 2.38038772e-05)
    list(9.23825e-09 -0.000431290335 0 1.99015878e-05)
    list(9.24025e-09 -0.000431270896 0 1.9349966e-05)
    list(9.24225e-09 -0.000431251676 0 1.90976748e-05)
    list(9.24425e-09 -0.000431231949 0 1.89543258e-05)
    list(9.24625e-09 -0.000431211484 0 1.88541773e-05)
    list(9.24825e-09 -0.000431190261 0 1.8763794e-05)
    list(9.25025e-09 -0.000431168343 0 1.86650342e-05)
    list(9.25225e-09 -0.000431145813 0 1.8550069e-05)
    list(9.25425e-09 -0.000431122753 0 1.8420311e-05)
    list(9.25625e-09 -0.000431099234 0 1.82840287e-05)
    list(9.25825e-09 -0.000431075313 0 1.81516852e-05)
    list(9.26025e-09 -0.000431051032 0 1.80317076e-05)
    list(9.26225e-09 -0.000431026419 0 1.7928699e-05)
    list(9.26425e-09 -0.000431001497 0 1.78437617e-05)
    list(9.26625e-09 -0.000430976285 0 1.7775694e-05)
    list(9.26825e-09 -0.0004309508 0 1.7722168e-05)
    list(9.27025e-09 -0.000430925058 0 1.76805513e-05)
    list(9.27225e-09 -0.000430899076 0 1.76483659e-05)
    list(9.27425e-09 -0.000430872868 0 1.76234871e-05)
    list(9.27625e-09 -0.000430846447 0 1.76041912e-05)
    list(9.27825e-09 -0.000430819826 0 1.75891271e-05)
    list(9.28025e-09 -0.000430793016 0 1.75772595e-05)
    list(9.28225e-09 -0.000430766024 0 1.75678059e-05)
    list(9.28425e-09 -0.000430738859 0 1.75601804e-05)
    list(9.28625e-09 -0.000430711528 0 1.75539461e-05)
    list(9.28825e-09 -0.000430684034 0 1.75487781e-05)
    list(9.29025e-09 -0.000430656382 0 1.75444342e-05)
    list(9.29225e-09 -0.000430628575 0 1.75407338e-05)
    list(9.29425e-09 -0.000430600617 0 1.75375416e-05)
    list(9.29625e-09 -0.00043057251 0 1.75347553e-05)
    list(9.29825e-09 -0.000430544256 0 1.75322975e-05)
    list(9.3e-09 -0.000430519424 0 1.75296703e-05)
    list(9.30075e-09 -0.000332056403 0.15 6.55102589e-06)
    list(9.30275e-09 -2.51434459e-05 0.55 -5.6480227e-06)
    list(9.30475e-09 0.000572665432 0.95 1.87809989e-05)
    list(9.30535e-09 0.000705694962 1 2.76357593e-05)
    list(9.30725e-09 0.000780432058 1 1.22442162e-05)
    list(9.30925e-09 0.000783357159 1 1.01896738e-05)
    list(9.31125e-09 0.000778827341 1 9.63521128e-06)
    list(9.31325e-09 0.000773818393 1 9.25291349e-06)
    list(9.31525e-09 0.000768805765 1 8.89958251e-06)
    list(9.31725e-09 0.000763824413 1 8.55736712e-06)
    list(9.31925e-09 0.000758876724 1 8.21804301e-06)
    list(9.32125e-09 0.000753962706 1 7.87036383e-06)
    list(9.32325e-09 0.000749082235 1 7.49233148e-06)
    list(9.32525e-09 0.000744235236 1 7.03913068e-06)
    list(9.32725e-09 0.000739421721 1 6.44941878e-06)
    list(9.32925e-09 0.000734641827 1 5.7166293e-06)
    list(9.33015e-09 0.000695811342 0.97 2.47716358e-05)
    list(9.33175e-09 0.000190414679 0.65 7.19719003e-06)
    list(9.33375e-09 -0.000278820043 0.25 5.39865072e-05)
    list(9.33505e-09 -0.000452088712 0 4.6766136e-05)
    list(9.33625e-09 -0.000452089249 0 2.38038488e-05)
    list(9.33825e-09 -0.000452069516 0 1.99018097e-05)
    list(9.34025e-09 -0.000452050056 0 1.93501789e-05)
    list(9.34225e-09 -0.000452030816 0 1.90978654e-05)
    list(9.34425e-09 -0.00045201107 0 1.8954492e-05)
    list(9.34625e-09 -0.000451990584 0 1.88543187e-05)
    list(9.34825e-09 -0.000451969342 0 1.87639108e-05)
    list(9.35025e-09 -0.000451947404 0 1.86651274e-05)
    list(9.35225e-09 -0.000451924854 0 1.85501409e-05)
    list(9.35425e-09 -0.000451901774 0 1.84203657e-05)
    list(9.35625e-09 -0.000451878236 0 1.82840712e-05)
    list(9.35825e-09 -0.000451854295 0 1.815172e-05)
    list(9.36025e-09 -0.000451829994 0 1.80317381e-05)
    list(9.36225e-09 -0.000451805361 0 1.79287271e-05)
    list(9.36425e-09 -0.000451780419 0 1.78437884e-05)
    list(9.36625e-09 -0.000451755187 0 1.77757197e-05)
    list(9.36825e-09 -0.000451729682 0 1.77221927e-05)
    list(9.37025e-09 -0.00045170392 0 1.76805749e-05)
    list(9.37225e-09 -0.000451677917 0 1.76483883e-05)
    list(9.37425e-09 -0.000451651688 0 1.76235084e-05)
    list(9.37625e-09 -0.000451625247 0 1.76042112e-05)
    list(9.37825e-09 -0.000451598606 0 1.7589146e-05)
    list(9.38025e-09 -0.000451571775 0 1.75772772e-05)
    list(9.38225e-09 -0.000451544763 0 1.75678226e-05)
    list(9.38425e-09 -0.000451517577 0 1.75601962e-05)
    list(9.38625e-09 -0.000451490225 0 1.7553961e-05)
    list(9.38825e-09 -0.00045146271 0 1.75487922e-05)
    list(9.39025e-09 -0.000451435037 0 1.75444477e-05)
    list(9.39225e-09 -0.00045140721 0 1.75407467e-05)
    list(9.39425e-09 -0.000451379231 0 1.7537554e-05)
    list(9.39625e-09 -0.000451351103 0 1.75347673e-05)
    list(9.39825e-09 -0.000451322827 0 1.75323091e-05)
    list(9.4e-09 -0.000451297977 0 1.75296816e-05)
    list(9.40075e-09 -0.000352833162 0.15 6.55098123e-06)
    list(9.40275e-09 -4.58703298e-05 0.55 -5.64685478e-06)
    list(9.40475e-09 0.000552076083 0.95 1.8780492e-05)
    list(9.40535e-09 0.000685147374 1 2.76357863e-05)
    list(9.40725e-09 0.000760013709 1 1.22441884e-05)
    list(9.40925e-09 0.000763087144 1 1.01920957e-05)
    list(9.41125e-09 0.000758693105 1 9.63715303e-06)
    list(9.41325e-09 0.000753818151 1 9.25463071e-06)
    list(9.41525e-09 0.000748938569 1 8.90111456e-06)
    list(9.41725e-09 0.000744089378 1 8.55873535e-06)
    list(9.41925e-09 0.000739272974 1 8.21926558e-06)
    list(9.42125e-09 0.000734489371 1 7.8714571e-06)
    list(9.42325e-09 0.000729738451 1 7.49331059e-06)
    list(9.42525e-09 0.000725020145 1 7.04001007e-06)
    list(9.42725e-09 0.000720334469 1 6.45021125e-06)
    list(9.42925e-09 0.000715681567 1 5.71734369e-06)
    list(9.43015e-09 0.00067690675 0.97 2.47620526e-05)
    list(9.43175e-09 0.000171591865 0.65 7.19066462e-06)
    list(9.43375e-09 -0.000297609632 0.25 5.39809366e-05)
    list(9.43505e-09 -0.000470880644 0 4.67657422e-05)
    list(9.43625e-09 -0.000470881171 0 2.3803823e-05)
    list(9.43825e-09 -0.000470861419 0 1.99020103e-05)
    list(9.44025e-09 -0.000470841942 0 1.93503713e-05)
    list(9.44225e-09 -0.000470822684 0 1.90980376e-05)
    list(9.44425e-09 -0.00047080292 0 1.89546421e-05)
    list(9.44625e-09 -0.000470782417 0 1.88544464e-05)
    list(9.44825e-09 -0.000470761157 0 1.87640164e-05)
    list(9.45025e-09 -0.000470739201 0 1.86652116e-05)
    list(9.45225e-09 -0.000470716634 0 1.85502059e-05)
    list(9.45425e-09 -0.000470693536 0 1.84204151e-05)
    list(9.45625e-09 -0.00047066998 0 1.82841096e-05)
    list(9.45825e-09 -0.000470646022 0 1.81517515e-05)
    list(9.46025e-09 -0.000470621702 0 1.80317656e-05)
    list(9.46225e-09 -0.000470597052 0 1.79287525e-05)
    list(9.46425e-09 -0.000470572092 0 1.78438125e-05)
    list(9.46625e-09 -0.000470546842 0 1.77757429e-05)
    list(9.46825e-09 -0.000470521319 0 1.7722215e-05)
    list(9.47025e-09 -0.000470495539 0 1.76805963e-05)
    list(9.47225e-09 -0.000470469518 0 1.76484087e-05)
    list(9.47425e-09 -0.000470443271 0 1.76235276e-05)
    list(9.47625e-09 -0.000470416812 0 1.76042293e-05)
    list(9.47825e-09 -0.000470390152 0 1.7589163e-05)
    list(9.48025e-09 -0.000470363303 0 1.75772933e-05)
    list(9.48225e-09 -0.000470336272 0 1.75678377e-05)
    list(9.48425e-09 -0.000470309068 0 1.75602104e-05)
    list(9.48625e-09 -0.000470281697 0 1.75539745e-05)
    list(9.48825e-09 -0.000470254164 0 1.7548805e-05)
    list(9.49025e-09 -0.000470226472 0 1.75444599e-05)
    list(9.49225e-09 -0.000470198627 0 1.75407584e-05)
    list(9.49425e-09 -0.000470170629 0 1.75375652e-05)
    list(9.49625e-09 -0.000470142482 0 1.75347782e-05)
    list(9.49825e-09 -0.000470114188 0 1.75323197e-05)
    list(9.5e-09 -0.000470089321 0 1.75296917e-05)
    list(9.50075e-09 -0.000371622883 0.15 6.55094391e-06)
    list(9.50275e-09 -6.461493e-05 0.55 -5.645792e-06)
    list(9.50475e-09 0.000533455883 0.95 1.87800339e-05)
    list(9.50535e-09 0.000666564943 1 2.76358084e-05)
    list(9.50725e-09 0.000741548156 1 1.22441629e-05)
    list(9.50925e-09 0.000744755743 1 1.01942862e-05)
    list(9.51125e-09 0.000740484503 1 9.63890936e-06)
    list(9.51325e-09 0.000735730736 1 9.25618393e-06)
    list(9.51525e-09 0.000730971482 1 8.90250028e-06)
    list(9.51725e-09 0.000726241818 1 8.55997288e-06)
    list(9.51925e-09 0.000721544149 1 8.22037133e-06)
    list(9.52125e-09 0.000716878495 1 7.87244591e-06)
    list(9.52325e-09 0.000712244742 1 7.49419614e-06)
    list(9.52525e-09 0.000707642826 1 7.0408054e-06)
    list(9.52725e-09 0.00070307277 1 6.45092796e-06)
    list(9.52925e-09 0.000698534719 1 5.71798977e-06)
    list(9.53015e-09 0.000659810249 0.97 2.47533811e-05)
    list(9.53175e-09 0.000154569317 0.65 7.1847609e-06)
    list(9.53375e-09 -0.000314602133 0.25 5.39758956e-05)
    list(9.53505e-09 -0.000487875263 0 4.67653855e-05)
    list(9.53625e-09 -0.000487875781 0 2.38037993e-05)
    list(9.53825e-09 -0.000487856013 0 1.99021914e-05)
    list(9.54025e-09 -0.00048783652 0 1.93505451e-05)
    list(9.54225e-09 -0.000487817246 0 1.90981931e-05)
    list(9.54425e-09 -0.000487797467 0 1.89547778e-05)
    list(9.54625e-09 -0.000487776948 0 1.88545618e-05)
    list(9.54825e-09 -0.000487755672 0 1.87641117e-05)
    list(9.55025e-09 -0.000487733701 0 1.86652876e-05)
    list(9.55225e-09 -0.000487711118 0 1.85502646e-05)
    list(9.55425e-09 -0.000487688004 0 1.84204598e-05)
    list(9.55625e-09 -0.000487664432 0 1.82841442e-05)
    list(9.55825e-09 -0.000487640458 0 1.81517799e-05)
    list(9.56025e-09 -0.000487616123 0 1.80317905e-05)
    list(9.56225e-09 -0.000487591457 0 1.79287755e-05)
    list(9.56425e-09 -0.000487566481 0 1.78438344e-05)
    list(9.56625e-09 -0.000487541215 0 1.77757639e-05)
    list(9.56825e-09 -0.000487515676 0 1.77222352e-05)
    list(9.57025e-09 -0.00048748988 0 1.76806156e-05)
    list(9.57225e-09 -0.000487463843 0 1.7648427e-05)
    list(9.57425e-09 -0.00048743758 0 1.7623545e-05)
    list(9.57625e-09 -0.000487411104 0 1.76042457e-05)
    list(9.57825e-09 -0.000487384428 0 1.75891784e-05)
    list(9.58025e-09 -0.000487357562 0 1.75773078e-05)
    list(9.58225e-09 -0.000487330515 0 1.75678514e-05)
    list(9.58425e-09 -0.000487303295 0 1.75602233e-05)
    list(9.58625e-09 -0.000487275907 0 1.75539867e-05)
    list(9.58825e-09 -0.000487248357 0 1.75488166e-05)
    list(9.59025e-09 -0.00048722065 0 1.75444709e-05)
    list(9.59225e-09 -0.000487192787 0 1.7540769e-05)
    list(9.59425e-09 -0.000487164773 0 1.75375754e-05)
    list(9.59625e-09 -0.000487136609 0 1.7534788e-05)
    list(9.59825e-09 -0.000487108298 0 1.75323292e-05)
    list(9.6e-09 -0.000487083416 0 1.75297009e-05)
    list(9.60075e-09 -0.000388615512 0.15 6.55091323e-06)
    list(9.60275e-09 -8.15667386e-05 0.55 -5.6448243e-06)
    list(9.60475e-09 0.000516616595 0.95 1.87796202e-05)
    list(9.60535e-09 0.000649759815 1 2.76358261e-05)
    list(9.60725e-09 0.000724848725 1 1.22441395e-05)
    list(9.60925e-09 0.000728177635 1 1.01962676e-05)
    list(9.61125e-09 0.000724017455 1 9.64049798e-06)
    list(9.61325e-09 0.000719373289 1 9.25758883e-06)
    list(9.61525e-09 0.00071472286 1 8.90375365e-06)
    list(9.61725e-09 0.000710101297 1 8.56109219e-06)
    list(9.61925e-09 0.000705511013 1 8.22137145e-06)
    list(9.62125e-09 0.000700952031 1 7.87334022e-06)
    list(9.62325e-09 0.000696424244 1 7.49499705e-06)
    list(9.62525e-09 0.000691927591 1 7.04152471e-06)
    list(9.62725e-09 0.0006874621 1 6.45157616e-06)
    list(9.62925e-09 0.000683027922 1 5.71857408e-06)
    list(9.63015e-09 0.000644348984 0.97 2.47455342e-05)
    list(9.63175e-09 0.000139174928 0.65 7.17941944e-06)
    list(9.63375e-09 -0.000329969349 0.25 5.39713335e-05)
    list(9.63505e-09 -0.000503244396 0 4.67650625e-05)
    list(9.63625e-09 -0.000503244906 0 2.38037776e-05)
    list(9.63825e-09 -0.000503225124 0 1.99023549e-05)
    list(9.64025e-09 -0.000503205617 0 1.93507021e-05)
    list(9.64225e-09 -0.000503186329 0 1.90983336e-05)
    list(9.64425e-09 -0.000503166535 0 1.89549003e-05)
    list(9.64625e-09 -0.000503146002 0 1.88546661e-05)
    list(9.64825e-09 -0.000503124713 0 1.87641978e-05)
    list(9.65025e-09 -0.000503102728 0 1.86653563e-05)
    list(9.65225e-09 -0.00050308013 0 1.85503176e-05)
    list(9.65425e-09 -0.000503057003 0 1.84205001e-05)
    list(9.65625e-09 -0.000503033417 0 1.82841755e-05)
    list(9.65825e-09 -0.000503009429 0 1.81518055e-05)
    list(9.66025e-09 -0.00050298508 0 1.80318129e-05)
    list(9.66225e-09 -0.0005029604 0 1.79287962e-05)
    list(9.66425e-09 -0.00050293541 0 1.78438541e-05)
    list(9.66625e-09 -0.00050291013 0 1.77757829e-05)
    list(9.66825e-09 -0.000502884576 0 1.77222534e-05)
    list(9.67025e-09 -0.000502858765 0 1.76806331e-05)
    list(9.67225e-09 -0.000502832714 0 1.76484436e-05)
    list(9.67425e-09 -0.000502806437 0 1.76235607e-05)
    list(9.67625e-09 -0.000502779947 0 1.76042605e-05)
    list(9.67825e-09 -0.000502753256 0 1.75891924e-05)
    list(9.68025e-09 -0.000502726376 0 1.75773209e-05)
    list(9.68225e-09 -0.000502699314 0 1.75678637e-05)
    list(9.68425e-09 -0.000502672079 0 1.75602349e-05)
    list(9.68625e-09 -0.000502644677 0 1.75539977e-05)
    list(9.68825e-09 -0.000502617113 0 1.75488271e-05)
    list(9.69025e-09 -0.00050258939 0 1.75444809e-05)
    list(9.69225e-09 -0.000502561513 0 1.75407786e-05)
    list(9.69425e-09 -0.000502533484 0 1.75375846e-05)
    list(9.69625e-09 -0.000502505305 0 1.75347968e-05)
    list(9.69825e-09 -0.000502476979 0 1.75323378e-05)
    list(9.7e-09 -0.000502452084 0 1.75297092e-05)
    list(9.70075e-09 -0.000403982854 0.15 6.55088855e-06)
    list(9.70275e-09 -9.68971516e-05 0.55 -5.64394259e-06)
    list(9.70475e-09 0.00050138796 0.95 1.87792467e-05)
    list(9.70535e-09 0.000634562076 1 2.76358398e-05)
    list(9.70725e-09 0.00070974657 1 1.22441179e-05)
    list(9.70925e-09 0.000713185206 1 1.01980601e-05)
    list(9.71125e-09 0.000709125469 1 9.64193504e-06)
    list(9.71325e-09 0.000704580425 1 9.25885966e-06)
    list(9.71525e-09 0.000700028416 1 8.90488739e-06)
    list(9.71725e-09 0.000695504619 1 8.56210465e-06)
    list(9.71925e-09 0.000691011452 1 8.22227607e-06)
    list(9.72125e-09 0.000686548943 1 7.87414913e-06)
    list(9.72325e-09 0.000682116991 1 7.49572146e-06)
    list(9.72525e-09 0.000677715537 1 7.04217531e-06)
    list(9.72725e-09 0.000673344614 1 6.45216242e-06)
    list(9.72925e-09 0.000669004376 1 5.71910256e-06)
    list(9.73015e-09 0.000630366617 0.97 2.47384331e-05)
    list(9.73175e-09 0.000125253035 0.65 7.17458647e-06)
    list(9.73375e-09 -0.000343866671 0.25 5.39672046e-05)
    list(9.73505e-09 -0.000517143451 0 4.67647699e-05)
    list(9.73625e-09 -0.000517143954 0 2.38037578e-05)
    list(9.73825e-09 -0.000517124159 0 1.99025026e-05)
    list(9.74025e-09 -0.000517104639 0 1.93508438e-05)
    list(9.74225e-09 -0.000517085339 0 1.90984605e-05)
    list(9.74425e-09 -0.000517065533 0 1.89550109e-05)
    list(9.74625e-09 -0.000517044988 0 1.88547603e-05)
    list(9.74825e-09 -0.000517023686 0 1.87642756e-05)
    list(9.75025e-09 -0.000517001688 0 1.86654183e-05)
    list(9.75225e-09 -0.000516979079 0 1.85503654e-05)
    list(9.75425e-09 -0.000516955939 0 1.84205365e-05)
    list(9.75625e-09 -0.000516932341 0 1.82842038e-05)
    list(9.75825e-09 -0.00051690834 0 1.81518287e-05)
    list(9.76025e-09 -0.000516883979 0 1.80318332e-05)
    list(9.76225e-09 -0.000516859286 0 1.79288149e-05)
    list(9.76425e-09 -0.000516834283 0 1.78438719e-05)
    list(9.76625e-09 -0.000516808991 0 1.77758e-05)
    list(9.76825e-09 -0.000516783424 0 1.77222699e-05)
    list(9.77025e-09 -0.000516757601 0 1.76806488e-05)
    list(9.77225e-09 -0.000516731537 0 1.76484586e-05)
    list(9.77425e-09 -0.000516705247 0 1.76235749e-05)
    list(9.77625e-09 -0.000516678744 0 1.76042739e-05)
    list(9.77825e-09 -0.000516652041 0 1.7589205e-05)
    list(9.78025e-09 -0.000516625148 0 1.75773327e-05)
    list(9.78225e-09 -0.000516598073 0 1.75678749e-05)
    list(9.78425e-09 -0.000516570825 0 1.75602455e-05)
    list(9.78625e-09 -0.00051654341 0 1.75540077e-05)
    list(9.78825e-09 -0.000516515832 0 1.75488365e-05)
    list(9.79025e-09 -0.000516488097 0 1.75444899e-05)
    list(9.79225e-09 -0.000516460206 0 1.75407872e-05)
    list(9.79425e-09 -0.000516432164 0 1.75375929e-05)
    list(9.79625e-09 -0.000516403973 0 1.75348049e-05)
    list(9.79825e-09 -0.000516375633 0 1.75323456e-05)
    list(9.8e-09 -0.000516350727 0 1.75297168e-05)
    list(9.80075e-09 -0.000417880297 0.15 6.55086931e-06)
    list(9.80275e-09 -0.000110761187 0.55 -5.64313863e-06)
    list(9.80475e-09 0.000487615987 0.95 1.87789095e-05)
    list(9.80535e-09 0.000620818046 1 2.763585e-05)
    list(9.80725e-09 0.000696088977 1 1.22440979e-05)
    list(9.80925e-09 0.00069962684 1 1.0199681e-05)
    list(9.81125e-09 0.00069565794 1 9.6432348e-06)
    list(9.81325e-09 0.000691202542 1 9.26000908e-06)
    list(9.81525e-09 0.000686739542 1 8.9059128e-06)
    list(9.81725e-09 0.000682304162 1 8.56302034e-06)
    list(9.81925e-09 0.000677898826 1 8.22309422e-06)
    list(9.82125e-09 0.000673523567 1 7.87488071e-06)
    list(9.82325e-09 0.000669178285 1 7.4963766e-06)
    list(9.82525e-09 0.000664862928 1 7.04276368e-06)
    list(9.82725e-09 0.00066057753 1 6.4526926e-06)
    list(9.82925e-09 0.00065632225 1 5.71958047e-06)
    list(9.83015e-09 0.000617721731 0.97 2.47320063e-05)
    list(9.83175e-09 0.000112662833 0.65 7.17021336e-06)
    list(9.83375e-09 -0.000356434653 0.25 5.39634675e-05)
    list(9.83505e-09 -0.000529713002 0 4.67645049e-05)
    list(9.83625e-09 -0.000529713498 0 2.38037396e-05)
    list(9.83825e-09 -0.000529693692 0 1.9902636e-05)
    list(9.84025e-09 -0.000529674161 0 1.93509718e-05)
    list(9.84225e-09 -0.00052965485 0 1.90985751e-05)
    list(9.84425e-09 -0.000529635033 0 1.89551109e-05)
    list(9.84625e-09 -0.000529614477 0 1.88548453e-05)
    list(9.84825e-09 -0.000529593164 0 1.87643459e-05)
    list(9.85025e-09 -0.000529571156 0 1.86654744e-05)
    list(9.85225e-09 -0.000529548535 0 1.85504087e-05)
    list(9.85425e-09 -0.000529525385 0 1.84205694e-05)
    list(9.85625e-09 -0.000529501776 0 1.82842293e-05)
    list(9.85825e-09 -0.000529477764 0 1.81518496e-05)
    list(9.86025e-09 -0.000529453392 0 1.80318515e-05)
    list(9.86225e-09 -0.000529428687 0 1.79288318e-05)
    list(9.86425e-09 -0.000529403674 0 1.7843888e-05)
    list(9.86625e-09 -0.00052937837 0 1.77758155e-05)
    list(9.86825e-09 -0.000529352793 0 1.77222848e-05)
    list(9.87025e-09 -0.000529326958 0 1.76806631e-05)
    list(9.87225e-09 -0.000529300883 0 1.76484722e-05)
    list(9.87425e-09 -0.000529274582 0 1.76235877e-05)
    list(9.87625e-09 -0.000529248067 0 1.76042861e-05)
    list(9.87825e-09 -0.000529221353 0 1.75892164e-05)
    list(9.88025e-09 -0.000529194448 0 1.75773435e-05)
    list(9.88225e-09 -0.000529167362 0 1.7567885e-05)
    list(9.88425e-09 -0.000529140103 0 1.7560255e-05)
    list(9.88625e-09 -0.000529112676 0 1.75540167e-05)
    list(9.88825e-09 -0.000529085087 0 1.75488451e-05)
    list(9.89025e-09 -0.00052905734 0 1.75444981e-05)
    list(9.89225e-09 -0.000529029438 0 1.7540795e-05)
    list(9.89425e-09 -0.000529001384 0 1.75376004e-05)
    list(9.89625e-09 -0.000528973181 0 1.75348121e-05)
    list(9.89825e-09 -0.00052894483 0 1.75323526e-05)
    list(9.9e-09 -0.000528919913 0 1.75297236e-05)
    list(9.90075e-09 -0.000430448399 0.15 6.55085498e-06)
    list(9.90275e-09 -0.000123299067 0.55 -5.64240501e-06)
    list(9.90475e-09 0.000475161383 0.95 1.87786051e-05)
    list(9.90535e-09 0.000608388716 1 2.76358569e-05)
    list(9.90725e-09 0.000683737811 1 1.22440795e-05)
    list(9.90925e-09 0.00068736541 1 1.02011471e-05)
    list(9.91125e-09 0.00068347866 1 9.6444105e-06)
    list(9.91325e-09 0.000679104335 1 9.26104878e-06)
    list(9.91525e-09 0.000674721834 1 8.90684031e-06)
    list(9.91725e-09 0.000670366416 1 8.56384859e-06)
    list(9.91925e-09 0.000666040512 1 8.22383422e-06)
    list(9.92125e-09 0.000661744159 1 7.87554238e-06)
    list(9.92325e-09 0.000657477261 1 7.49696914e-06)
    list(9.92525e-09 0.000653239766 1 7.04329581e-06)
    list(9.92725e-09 0.000649031715 1 6.4531721e-06)
    list(9.92925e-09 0.00064485327 1 5.72001269e-06)
    list(9.93015e-09 0.000606286429 0.97 2.47261896e-05)
    list(9.93175e-09 0.000101276978 0.65 7.16625613e-06)
    list(9.93375e-09 -0.000367800418 0.25 5.39600846e-05)
    list(9.93505e-09 -0.000541080185 0 4.67642648e-05)
    list(9.93625e-09 -0.000541080676 0 2.38037228e-05)
    list(9.93825e-09 -0.00054106086 0 1.99027563e-05)
    list(9.94025e-09 -0.000541041319 0 1.93510874e-05)
    list(9.94225e-09 -0.000541021998 0 1.90986786e-05)
    list(9.94425e-09 -0.000541002172 0 1.89552012e-05)
    list(9.94625e-09 -0.000540981606 0 1.88549221e-05)
    list(9.94825e-09 -0.000540960283 0 1.87644093e-05)
    list(9.95025e-09 -0.000540938265 0 1.8665525e-05)
    list(9.95225e-09 -0.000540915635 0 1.85504477e-05)
    list(9.95425e-09 -0.000540892475 0 1.84205991e-05)
    list(9.95625e-09 -0.000540868856 0 1.82842523e-05)
    list(9.95825e-09 -0.000540844835 0 1.81518685e-05)
    list(9.96025e-09 -0.000540820453 0 1.8031868e-05)
    list(9.96225e-09 -0.000540795739 0 1.79288471e-05)
    list(9.96425e-09 -0.000540770716 0 1.78439026e-05)
    list(9.96625e-09 -0.000540745402 0 1.77758295e-05)
    list(9.96825e-09 -0.000540719815 0 1.77222983e-05)
    list(9.97025e-09 -0.000540693971 0 1.7680676e-05)
    list(9.97225e-09 -0.000540667886 0 1.76484845e-05)
    list(9.97425e-09 -0.000540641574 0 1.76235993e-05)
    list(9.97625e-09 -0.00054061505 0 1.7604297e-05)
    list(9.97825e-09 -0.000540588325 0 1.75892267e-05)
    list(9.98025e-09 -0.000540561411 0 1.75773532e-05)
    list(9.98225e-09 -0.000540534315 0 1.75678941e-05)
    list(9.98425e-09 -0.000540507045 0 1.75602636e-05)
    list(9.98625e-09 -0.000540479608 0 1.75540249e-05)
    list(9.98825e-09 -0.000540452009 0 1.75488529e-05)
    list(9.99025e-09 -0.000540424252 0 1.75445055e-05)
    list(9.99225e-09 -0.000540396339 0 1.75408021e-05)
    list(9.99425e-09 -0.000540368275 0 1.75376072e-05)
    list(9.99625e-09 -0.000540340062 0 1.75348187e-05)
    list(9.99825e-09 -0.000540311701 0 1.7532359e-05)
    list(1e-08 -0.000540286775 0 1.75297297e-05)
  )
  n = length(rows)
  x = drCreateVec('double n)
  y = drCreateVec('double n)
  ctl = drCreateVec('double n)
  watts = drCreateVec('double n)
  k = 0
  foreach(row rows
    drSetElem(x k car(row))
    drSetElem(y k cadr(row))
    drSetElem(ctl k caddr(row))
    drSetElem(watts k cadddr(row))
    k = k + 1
  )
  printf("discharging: %d measured points plotted (display decimated 4:1)\n" n)
  plot(drCreateWaveform(x y) ?expr list("ngspice imported: discharging Vop (V)"))
  plot(drCreateWaveform(x ctl) ?expr list("ngspice imported: discharging control (V)"))
  plot(drCreateWaveform(x watts) ?expr list("ngspice imported: discharging VDD power (W)"))
)
printf("Charge delay: 13.8114 ps; discharge delay: 15.4473 ps\n")
printf("Charge power: 22.5280 uW; discharge power: 16.0966 uW\n")
printf("10%% current-compliance dynamic range valid: NO\n")
