printf("EDGE16_PS %g\n" let((d a b t0 vlo vhi) d="/home/shivam/Projects/VLSI/mcml_charge_pump_10ghz_project/mcml_cp_sim/verified_flow/results/viva_psf_discharge" a=getData("DN" ?result 'tran ?resultsDir d) b=getData("Vop" ?result 'tran ?resultsDir d) t0=cross(a 0.5 16 "rising") vlo=value(b t0-10e-12) vhi=value(b t0+40e-12) (cross(clip(b t0 t0+40e-12) (vlo+vhi)/2 1 "falling")-t0)*1e12))
printf("CHARGE_PS %g\n" let((d a b sum n ti vlo vhi) d="/home/shivam/Projects/VLSI/mcml_charge_pump_10ghz_project/mcml_cp_sim/verified_flow/results/viva_psf_charge" a=getData("UP" ?result 'tran ?resultsDir d) b=getData("Vop" ?result 'tran ?resultsDir d) sum=0.0 for(n 11 20 ti=cross(a 0.5 n "rising") vlo=value(b ti-10e-12) vhi=value(b ti+40e-12) sum=sum+cross(clip(b ti ti+40e-12) (vlo+vhi)/2 1 "rising")-ti) sum/10*1e12))
printf("DISCHARGE_PS %g\n" let((d a b sum n ti vlo vhi) d="/home/shivam/Projects/VLSI/mcml_charge_pump_10ghz_project/mcml_cp_sim/verified_flow/results/viva_psf_discharge" a=getData("DN" ?result 'tran ?resultsDir d) b=getData("Vop" ?result 'tran ?resultsDir d) sum=0.0 for(n 11 20 ti=cross(a 0.5 n "rising") vlo=value(b ti-10e-12) vhi=value(b ti+40e-12) sum=sum+cross(clip(b ti ti+40e-12) (vlo+vhi)/2 1 "falling")-ti) sum/10*1e12))
printf("PAPER_ERROR_PCT %g\n" let((d a b sum n ti vlo vhi measured) d="/home/shivam/Projects/VLSI/mcml_charge_pump_10ghz_project/mcml_cp_sim/verified_flow/results/viva_psf_discharge" a=getData("DN" ?result 'tran ?resultsDir d) b=getData("Vop" ?result 'tran ?resultsDir d) sum=0.0 for(n 11 20 ti=cross(a 0.5 n "rising") vlo=value(b ti-10e-12) vhi=value(b ti+40e-12) sum=sum+cross(clip(b ti ti+40e-12) (vlo+vhi)/2 1 "falling")-ti) measured=sum/10*1e12 100*abs(measured-16.71)/16.71))
exit()
