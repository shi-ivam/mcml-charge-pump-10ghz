simulator('spectre)
design("shivam" "tb_mcml_charge_pump" "schematic")
modelFile(list(list("/home/shivam/Projects/VLSI/mcml_charge_pump_10ghz_project/cadence_work/gpdk045.scs" "mc")))
temp(27)
analysis('tran ?stop "10n" ?maxstep "0.5p")
saveOption('save "allpub")
run()
printf("BRIDGE_OCEAN_RUN_FINISHED\n")
r = openResults("/home/shivam/simulation/tb_mcml_charge_pump/spectre/schematic/psf")
printf("BRIDGE_RESULTS %L\n" r)
when(r
  selectResult('tran)
  w = getData("Vbias")
  printf("BRIDGE_VBIAS %L\n" w)
  when(w
    xv = drGetWaveformXVec(w)
    yv = drGetWaveformYVec(w)
    printf("BRIDGE_VBIAS_LAST %.12g %.12g\n" drGetElem(xv drVectorLength(xv)-1) drGetElem(yv drVectorLength(yv)-1))
  )
)
exit()
