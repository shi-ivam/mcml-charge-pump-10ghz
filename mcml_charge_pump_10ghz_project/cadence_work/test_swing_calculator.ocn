printf("HIGH_V %g\n" let((d v u sum n) d="/home/shivam/Projects/VLSI/mcml_charge_pump_10ghz_project/mcml_cp_sim/verified_flow/results/viva_psf_swing_charge" v=getData("Vop" ?result 'tran ?resultsDir d) u=getData("UP" ?result 'tran ?resultsDir d) sum=0.0 for(n 796 800 sum=sum+value(v cross(u 0.5 n "rising")-5e-12)) sum/5))
printf("LOW_V %g\n" let((d v u sum n) d="/home/shivam/Projects/VLSI/mcml_charge_pump_10ghz_project/mcml_cp_sim/verified_flow/results/viva_psf_swing_discharge" v=getData("Vop" ?result 'tran ?resultsDir d) u=getData("DN" ?result 'tran ?resultsDir d) sum=0.0 for(n 796 800 sum=sum+value(v cross(u 0.5 n "rising")-5e-12)) sum/5))
printf("SWING_V %g\n" let((cd dd cv dv cu du high low n) cd="/home/shivam/Projects/VLSI/mcml_charge_pump_10ghz_project/mcml_cp_sim/verified_flow/results/viva_psf_swing_charge" dd="/home/shivam/Projects/VLSI/mcml_charge_pump_10ghz_project/mcml_cp_sim/verified_flow/results/viva_psf_swing_discharge" cv=getData("Vop" ?result 'tran ?resultsDir cd) dv=getData("Vop" ?result 'tran ?resultsDir dd) cu=getData("UP" ?result 'tran ?resultsDir cd) du=getData("DN" ?result 'tran ?resultsDir dd) high=0.0 low=0.0 for(n 796 800 high=high+value(cv cross(cu 0.5 n "rising")-5e-12) low=low+value(dv cross(du 0.5 n "rising")-5e-12)) (high-low)/5))
exit()
