printf("HIGH_V %.12f\n" let((d v) d="/home/shivam/Projects/VLSI/mcml_charge_pump_10ghz_project/mcml_cp_sim/verified_flow/results/viva_psf_swing_charge" v=getData("Vop" ?result 'tran ?resultsDir d) (value(v 79.4975e-9)+value(v 79.5975e-9)+value(v 79.6975e-9)+value(v 79.7975e-9)+value(v 79.8975e-9))/5))
printf("LOW_V %.12f\n" let((d v) d="/home/shivam/Projects/VLSI/mcml_charge_pump_10ghz_project/mcml_cp_sim/verified_flow/results/viva_psf_swing_discharge" v=getData("Vop" ?result 'tran ?resultsDir d) (value(v 79.4975e-9)+value(v 79.5975e-9)+value(v 79.6975e-9)+value(v 79.7975e-9)+value(v 79.8975e-9))/5))
exit()
