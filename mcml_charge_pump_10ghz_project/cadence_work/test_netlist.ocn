simulator('spectre)
design("shivam" "mcml_charge_pump" "schematic")
createNetlist(?display nil)
exit()
